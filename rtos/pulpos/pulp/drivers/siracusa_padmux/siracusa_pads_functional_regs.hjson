
{
    # File auto-generated by Padrick unknown
    name: "siracusa_pads_functional_config"
    clock_primary: "clk_i"
    reset_primary: "rst_ni"
    bus_interfaces: [
        { protocol: "reg_iface", direction: "device"}
    ]
    regwidth: 32,
    registers: [
        {skipto: "0x0"},
























      {
          name: PAD_GPIO00_CFG
          desc: '''
            Pad signal configuration.
          '''
          swaccess: "rw"
          fields: [
            {
                bits: "0"
                name: chip2pad
                desc: '''
                     Connects to pad's TX driver
                '''
                swaccess: "rw"
                hwaccess: "hro"
                resval: "0"
            },
            {
                bits: "1"
                name: drv0
                desc: '''
                     Choose the driving strength of the pad. LSB = ~3mA
                '''
                swaccess: "rw"
                hwaccess: "hro"
                resval: "0"
            },
            {
                bits: "2"
                name: drv1
                desc: '''
                     Choose the driving strength of the pad. LSB = ~3mA
                '''
                swaccess: "rw"
                hwaccess: "hro"
                resval: "0"
            },
            {
                bits: "3"
                name: drv2
                desc: '''
                     Choose the driving strength of the pad. LSB = ~3mA
                '''
                swaccess: "rw"
                hwaccess: "hro"
                resval: "0"
            },
            {
                bits: "4"
                name: drv3
                desc: '''
                     Choose the driving strength of the pad. LSB = ~3mA
                '''
                swaccess: "rw"
                hwaccess: "hro"
                resval: "1"
            },
            {
                bits: "5"
                name: pull_en
                desc: '''
                     Enable pull up/down (depends on pull_sel) resistor, active-high
                '''
                swaccess: "rw"
                hwaccess: "hro"
                resval: "0"
            },
            {
                bits: "6"
                name: pull_sel
                desc: '''
                     1 -> use pull-up resistor (if pull_en == 1), 0 -> use pull-down resistor
                '''
                swaccess: "rw"
                hwaccess: "hro"
                resval: "0"
            },
            {
                bits: "7"
                name: ret_en
                desc: '''
                     Enable retention mode, active-high
                '''
                swaccess: "rw"
                hwaccess: "hro"
                resval: "0"
            },
            {
                bits: "8"
                name: st_en
                desc: '''
                     Schmitt-trigger enable, active high
                '''
                swaccess: "rw"
                hwaccess: "hro"
                resval: "0"
            },
            {
                bits: "9"
                name: tx_en
                desc: '''
                     TX driver enable, active low
                '''
                swaccess: "rw"
                hwaccess: "hro"
                resval: "0"
            },
          ]
      }

       {
          name: PAD_GPIO00_MUX_SEL
          desc: '''
              Pad signal port multiplex selection for pad pad_gpio00. The programmed value defines which port
              is connected to the pad.
          '''
          swaccess: "rw"
          hwaccess: "hro"
          resval: 0
          fields: [
              {
                  bits: "4:0"
                  enum: [
                      { value: "0", name: "register", desc: "Connects the Pad to the internal configuration register."}
                      { value: "1", name: "port_gpio_gpio00", desc: "Connect port gpio00 from port group gpio to this pad." }
                      { value: "2", name: "port_i2c0_scl", desc: "Connect port scl from port group i2c0 to this pad." }
                      { value: "3", name: "port_i2c0_sda", desc: "Connect port sda from port group i2c0 to this pad." }
                      { value: "4", name: "port_i3c0_puc", desc: "Connect port puc from port group i3c0 to this pad." }
                      { value: "5", name: "port_i3c0_scl", desc: "Connect port scl from port group i3c0 to this pad." }
                      { value: "6", name: "port_i3c0_sda", desc: "Connect port sda from port group i3c0 to this pad." }
                      { value: "7", name: "port_i3c1_puc", desc: "Connect port puc from port group i3c1 to this pad." }
                      { value: "8", name: "port_i3c1_scl", desc: "Connect port scl from port group i3c1 to this pad." }
                      { value: "9", name: "port_i3c1_sda", desc: "Connect port sda from port group i3c1 to this pad." }
                      { value: "10", name: "port_qspim0_csn0", desc: "Connect port csn0 from port group qspim0 to this pad." }
                      { value: "11", name: "port_qspim0_csn1", desc: "Connect port csn1 from port group qspim0 to this pad." }
                      { value: "12", name: "port_qspim0_csn2", desc: "Connect port csn2 from port group qspim0 to this pad." }
                      { value: "13", name: "port_qspim0_csn3", desc: "Connect port csn3 from port group qspim0 to this pad." }
                      { value: "14", name: "port_qspim0_sck", desc: "Connect port sck from port group qspim0 to this pad." }
                      { value: "15", name: "port_qspim0_sdio0", desc: "Connect port sdio0 from port group qspim0 to this pad." }
                      { value: "16", name: "port_qspim0_sdio1", desc: "Connect port sdio1 from port group qspim0 to this pad." }
                      { value: "17", name: "port_qspim0_sdio2", desc: "Connect port sdio2 from port group qspim0 to this pad." }
                      { value: "18", name: "port_qspim0_sdio3", desc: "Connect port sdio3 from port group qspim0 to this pad." }
                      { value: "19", name: "port_qspis0_csn", desc: "Connect port csn from port group qspis0 to this pad." }
                      { value: "20", name: "port_qspis0_sck", desc: "Connect port sck from port group qspis0 to this pad." }
                      { value: "21", name: "port_qspis0_sdio0", desc: "Connect port sdio0 from port group qspis0 to this pad." }
                      { value: "22", name: "port_qspis0_sdio1", desc: "Connect port sdio1 from port group qspis0 to this pad." }
                      { value: "23", name: "port_qspis0_sdio2", desc: "Connect port sdio2 from port group qspis0 to this pad." }
                      { value: "24", name: "port_qspis0_sdio3", desc: "Connect port sdio3 from port group qspis0 to this pad." }
                      { value: "25", name: "port_uart0_rx", desc: "Connect port rx from port group uart0 to this pad." }
                      { value: "26", name: "port_uart0_tx", desc: "Connect port tx from port group uart0 to this pad." }
                  ]
              }
          ]
      }

      {
          name: PAD_GPIO01_CFG
          desc: '''
            Pad signal configuration.
          '''
          swaccess: "rw"
          fields: [
            {
                bits: "0"
                name: chip2pad
                desc: '''
                     Connects to pad's TX driver
                '''
                swaccess: "rw"
                hwaccess: "hro"
                resval: "0"
            },
            {
                bits: "1"
                name: drv0
                desc: '''
                     Choose the driving strength of the pad. LSB = ~3mA
                '''
                swaccess: "rw"
                hwaccess: "hro"
                resval: "0"
            },
            {
                bits: "2"
                name: drv1
                desc: '''
                     Choose the driving strength of the pad. LSB = ~3mA
                '''
                swaccess: "rw"
                hwaccess: "hro"
                resval: "0"
            },
            {
                bits: "3"
                name: drv2
                desc: '''
                     Choose the driving strength of the pad. LSB = ~3mA
                '''
                swaccess: "rw"
                hwaccess: "hro"
                resval: "0"
            },
            {
                bits: "4"
                name: drv3
                desc: '''
                     Choose the driving strength of the pad. LSB = ~3mA
                '''
                swaccess: "rw"
                hwaccess: "hro"
                resval: "1"
            },
            {
                bits: "5"
                name: pull_en
                desc: '''
                     Enable pull up/down (depends on pull_sel) resistor, active-high
                '''
                swaccess: "rw"
                hwaccess: "hro"
                resval: "0"
            },
            {
                bits: "6"
                name: pull_sel
                desc: '''
                     1 -> use pull-up resistor (if pull_en == 1), 0 -> use pull-down resistor
                '''
                swaccess: "rw"
                hwaccess: "hro"
                resval: "0"
            },
            {
                bits: "7"
                name: ret_en
                desc: '''
                     Enable retention mode, active-high
                '''
                swaccess: "rw"
                hwaccess: "hro"
                resval: "0"
            },
            {
                bits: "8"
                name: st_en
                desc: '''
                     Schmitt-trigger enable, active high
                '''
                swaccess: "rw"
                hwaccess: "hro"
                resval: "0"
            },
            {
                bits: "9"
                name: tx_en
                desc: '''
                     TX driver enable, active low
                '''
                swaccess: "rw"
                hwaccess: "hro"
                resval: "0"
            },
          ]
      }

       {
          name: PAD_GPIO01_MUX_SEL
          desc: '''
              Pad signal port multiplex selection for pad pad_gpio01. The programmed value defines which port
              is connected to the pad.
          '''
          swaccess: "rw"
          hwaccess: "hro"
          resval: 0
          fields: [
              {
                  bits: "4:0"
                  enum: [
                      { value: "0", name: "register", desc: "Connects the Pad to the internal configuration register."}
                      { value: "1", name: "port_gpio_gpio01", desc: "Connect port gpio01 from port group gpio to this pad." }
                      { value: "2", name: "port_i2c0_scl", desc: "Connect port scl from port group i2c0 to this pad." }
                      { value: "3", name: "port_i2c0_sda", desc: "Connect port sda from port group i2c0 to this pad." }
                      { value: "4", name: "port_i3c0_puc", desc: "Connect port puc from port group i3c0 to this pad." }
                      { value: "5", name: "port_i3c0_scl", desc: "Connect port scl from port group i3c0 to this pad." }
                      { value: "6", name: "port_i3c0_sda", desc: "Connect port sda from port group i3c0 to this pad." }
                      { value: "7", name: "port_i3c1_puc", desc: "Connect port puc from port group i3c1 to this pad." }
                      { value: "8", name: "port_i3c1_scl", desc: "Connect port scl from port group i3c1 to this pad." }
                      { value: "9", name: "port_i3c1_sda", desc: "Connect port sda from port group i3c1 to this pad." }
                      { value: "10", name: "port_qspim0_csn0", desc: "Connect port csn0 from port group qspim0 to this pad." }
                      { value: "11", name: "port_qspim0_csn1", desc: "Connect port csn1 from port group qspim0 to this pad." }
                      { value: "12", name: "port_qspim0_csn2", desc: "Connect port csn2 from port group qspim0 to this pad." }
                      { value: "13", name: "port_qspim0_csn3", desc: "Connect port csn3 from port group qspim0 to this pad." }
                      { value: "14", name: "port_qspim0_sck", desc: "Connect port sck from port group qspim0 to this pad." }
                      { value: "15", name: "port_qspim0_sdio0", desc: "Connect port sdio0 from port group qspim0 to this pad." }
                      { value: "16", name: "port_qspim0_sdio1", desc: "Connect port sdio1 from port group qspim0 to this pad." }
                      { value: "17", name: "port_qspim0_sdio2", desc: "Connect port sdio2 from port group qspim0 to this pad." }
                      { value: "18", name: "port_qspim0_sdio3", desc: "Connect port sdio3 from port group qspim0 to this pad." }
                      { value: "19", name: "port_qspis0_csn", desc: "Connect port csn from port group qspis0 to this pad." }
                      { value: "20", name: "port_qspis0_sck", desc: "Connect port sck from port group qspis0 to this pad." }
                      { value: "21", name: "port_qspis0_sdio0", desc: "Connect port sdio0 from port group qspis0 to this pad." }
                      { value: "22", name: "port_qspis0_sdio1", desc: "Connect port sdio1 from port group qspis0 to this pad." }
                      { value: "23", name: "port_qspis0_sdio2", desc: "Connect port sdio2 from port group qspis0 to this pad." }
                      { value: "24", name: "port_qspis0_sdio3", desc: "Connect port sdio3 from port group qspis0 to this pad." }
                      { value: "25", name: "port_uart0_rx", desc: "Connect port rx from port group uart0 to this pad." }
                      { value: "26", name: "port_uart0_tx", desc: "Connect port tx from port group uart0 to this pad." }
                  ]
              }
          ]
      }

      {
          name: PAD_GPIO02_CFG
          desc: '''
            Pad signal configuration.
          '''
          swaccess: "rw"
          fields: [
            {
                bits: "0"
                name: chip2pad
                desc: '''
                     Connects to pad's TX driver
                '''
                swaccess: "rw"
                hwaccess: "hro"
                resval: "0"
            },
            {
                bits: "1"
                name: drv0
                desc: '''
                     Choose the driving strength of the pad. LSB = ~3mA
                '''
                swaccess: "rw"
                hwaccess: "hro"
                resval: "0"
            },
            {
                bits: "2"
                name: drv1
                desc: '''
                     Choose the driving strength of the pad. LSB = ~3mA
                '''
                swaccess: "rw"
                hwaccess: "hro"
                resval: "0"
            },
            {
                bits: "3"
                name: drv2
                desc: '''
                     Choose the driving strength of the pad. LSB = ~3mA
                '''
                swaccess: "rw"
                hwaccess: "hro"
                resval: "0"
            },
            {
                bits: "4"
                name: drv3
                desc: '''
                     Choose the driving strength of the pad. LSB = ~3mA
                '''
                swaccess: "rw"
                hwaccess: "hro"
                resval: "1"
            },
            {
                bits: "5"
                name: pull_en
                desc: '''
                     Enable pull up/down (depends on pull_sel) resistor, active-high
                '''
                swaccess: "rw"
                hwaccess: "hro"
                resval: "0"
            },
            {
                bits: "6"
                name: pull_sel
                desc: '''
                     1 -> use pull-up resistor (if pull_en == 1), 0 -> use pull-down resistor
                '''
                swaccess: "rw"
                hwaccess: "hro"
                resval: "0"
            },
            {
                bits: "7"
                name: ret_en
                desc: '''
                     Enable retention mode, active-high
                '''
                swaccess: "rw"
                hwaccess: "hro"
                resval: "0"
            },
            {
                bits: "8"
                name: st_en
                desc: '''
                     Schmitt-trigger enable, active high
                '''
                swaccess: "rw"
                hwaccess: "hro"
                resval: "0"
            },
            {
                bits: "9"
                name: tx_en
                desc: '''
                     TX driver enable, active low
                '''
                swaccess: "rw"
                hwaccess: "hro"
                resval: "0"
            },
          ]
      }

       {
          name: PAD_GPIO02_MUX_SEL
          desc: '''
              Pad signal port multiplex selection for pad pad_gpio02. The programmed value defines which port
              is connected to the pad.
          '''
          swaccess: "rw"
          hwaccess: "hro"
          resval: 0
          fields: [
              {
                  bits: "4:0"
                  enum: [
                      { value: "0", name: "register", desc: "Connects the Pad to the internal configuration register."}
                      { value: "1", name: "port_gpio_gpio02", desc: "Connect port gpio02 from port group gpio to this pad." }
                      { value: "2", name: "port_i2c0_scl", desc: "Connect port scl from port group i2c0 to this pad." }
                      { value: "3", name: "port_i2c0_sda", desc: "Connect port sda from port group i2c0 to this pad." }
                      { value: "4", name: "port_i3c0_puc", desc: "Connect port puc from port group i3c0 to this pad." }
                      { value: "5", name: "port_i3c0_scl", desc: "Connect port scl from port group i3c0 to this pad." }
                      { value: "6", name: "port_i3c0_sda", desc: "Connect port sda from port group i3c0 to this pad." }
                      { value: "7", name: "port_i3c1_puc", desc: "Connect port puc from port group i3c1 to this pad." }
                      { value: "8", name: "port_i3c1_scl", desc: "Connect port scl from port group i3c1 to this pad." }
                      { value: "9", name: "port_i3c1_sda", desc: "Connect port sda from port group i3c1 to this pad." }
                      { value: "10", name: "port_qspim0_csn0", desc: "Connect port csn0 from port group qspim0 to this pad." }
                      { value: "11", name: "port_qspim0_csn1", desc: "Connect port csn1 from port group qspim0 to this pad." }
                      { value: "12", name: "port_qspim0_csn2", desc: "Connect port csn2 from port group qspim0 to this pad." }
                      { value: "13", name: "port_qspim0_csn3", desc: "Connect port csn3 from port group qspim0 to this pad." }
                      { value: "14", name: "port_qspim0_sck", desc: "Connect port sck from port group qspim0 to this pad." }
                      { value: "15", name: "port_qspim0_sdio0", desc: "Connect port sdio0 from port group qspim0 to this pad." }
                      { value: "16", name: "port_qspim0_sdio1", desc: "Connect port sdio1 from port group qspim0 to this pad." }
                      { value: "17", name: "port_qspim0_sdio2", desc: "Connect port sdio2 from port group qspim0 to this pad." }
                      { value: "18", name: "port_qspim0_sdio3", desc: "Connect port sdio3 from port group qspim0 to this pad." }
                      { value: "19", name: "port_qspis0_csn", desc: "Connect port csn from port group qspis0 to this pad." }
                      { value: "20", name: "port_qspis0_sck", desc: "Connect port sck from port group qspis0 to this pad." }
                      { value: "21", name: "port_qspis0_sdio0", desc: "Connect port sdio0 from port group qspis0 to this pad." }
                      { value: "22", name: "port_qspis0_sdio1", desc: "Connect port sdio1 from port group qspis0 to this pad." }
                      { value: "23", name: "port_qspis0_sdio2", desc: "Connect port sdio2 from port group qspis0 to this pad." }
                      { value: "24", name: "port_qspis0_sdio3", desc: "Connect port sdio3 from port group qspis0 to this pad." }
                      { value: "25", name: "port_uart0_rx", desc: "Connect port rx from port group uart0 to this pad." }
                      { value: "26", name: "port_uart0_tx", desc: "Connect port tx from port group uart0 to this pad." }
                  ]
              }
          ]
      }

      {
          name: PAD_GPIO03_CFG
          desc: '''
            Pad signal configuration.
          '''
          swaccess: "rw"
          fields: [
            {
                bits: "0"
                name: chip2pad
                desc: '''
                     Connects to pad's TX driver
                '''
                swaccess: "rw"
                hwaccess: "hro"
                resval: "0"
            },
            {
                bits: "1"
                name: drv0
                desc: '''
                     Choose the driving strength of the pad. LSB = ~3mA
                '''
                swaccess: "rw"
                hwaccess: "hro"
                resval: "0"
            },
            {
                bits: "2"
                name: drv1
                desc: '''
                     Choose the driving strength of the pad. LSB = ~3mA
                '''
                swaccess: "rw"
                hwaccess: "hro"
                resval: "0"
            },
            {
                bits: "3"
                name: drv2
                desc: '''
                     Choose the driving strength of the pad. LSB = ~3mA
                '''
                swaccess: "rw"
                hwaccess: "hro"
                resval: "0"
            },
            {
                bits: "4"
                name: drv3
                desc: '''
                     Choose the driving strength of the pad. LSB = ~3mA
                '''
                swaccess: "rw"
                hwaccess: "hro"
                resval: "1"
            },
            {
                bits: "5"
                name: pull_en
                desc: '''
                     Enable pull up/down (depends on pull_sel) resistor, active-high
                '''
                swaccess: "rw"
                hwaccess: "hro"
                resval: "0"
            },
            {
                bits: "6"
                name: pull_sel
                desc: '''
                     1 -> use pull-up resistor (if pull_en == 1), 0 -> use pull-down resistor
                '''
                swaccess: "rw"
                hwaccess: "hro"
                resval: "0"
            },
            {
                bits: "7"
                name: ret_en
                desc: '''
                     Enable retention mode, active-high
                '''
                swaccess: "rw"
                hwaccess: "hro"
                resval: "0"
            },
            {
                bits: "8"
                name: st_en
                desc: '''
                     Schmitt-trigger enable, active high
                '''
                swaccess: "rw"
                hwaccess: "hro"
                resval: "0"
            },
            {
                bits: "9"
                name: tx_en
                desc: '''
                     TX driver enable, active low
                '''
                swaccess: "rw"
                hwaccess: "hro"
                resval: "0"
            },
          ]
      }

       {
          name: PAD_GPIO03_MUX_SEL
          desc: '''
              Pad signal port multiplex selection for pad pad_gpio03. The programmed value defines which port
              is connected to the pad.
          '''
          swaccess: "rw"
          hwaccess: "hro"
          resval: 0
          fields: [
              {
                  bits: "4:0"
                  enum: [
                      { value: "0", name: "register", desc: "Connects the Pad to the internal configuration register."}
                      { value: "1", name: "port_gpio_gpio03", desc: "Connect port gpio03 from port group gpio to this pad." }
                      { value: "2", name: "port_i2c0_scl", desc: "Connect port scl from port group i2c0 to this pad." }
                      { value: "3", name: "port_i2c0_sda", desc: "Connect port sda from port group i2c0 to this pad." }
                      { value: "4", name: "port_i3c0_puc", desc: "Connect port puc from port group i3c0 to this pad." }
                      { value: "5", name: "port_i3c0_scl", desc: "Connect port scl from port group i3c0 to this pad." }
                      { value: "6", name: "port_i3c0_sda", desc: "Connect port sda from port group i3c0 to this pad." }
                      { value: "7", name: "port_i3c1_puc", desc: "Connect port puc from port group i3c1 to this pad." }
                      { value: "8", name: "port_i3c1_scl", desc: "Connect port scl from port group i3c1 to this pad." }
                      { value: "9", name: "port_i3c1_sda", desc: "Connect port sda from port group i3c1 to this pad." }
                      { value: "10", name: "port_qspim0_csn0", desc: "Connect port csn0 from port group qspim0 to this pad." }
                      { value: "11", name: "port_qspim0_csn1", desc: "Connect port csn1 from port group qspim0 to this pad." }
                      { value: "12", name: "port_qspim0_csn2", desc: "Connect port csn2 from port group qspim0 to this pad." }
                      { value: "13", name: "port_qspim0_csn3", desc: "Connect port csn3 from port group qspim0 to this pad." }
                      { value: "14", name: "port_qspim0_sck", desc: "Connect port sck from port group qspim0 to this pad." }
                      { value: "15", name: "port_qspim0_sdio0", desc: "Connect port sdio0 from port group qspim0 to this pad." }
                      { value: "16", name: "port_qspim0_sdio1", desc: "Connect port sdio1 from port group qspim0 to this pad." }
                      { value: "17", name: "port_qspim0_sdio2", desc: "Connect port sdio2 from port group qspim0 to this pad." }
                      { value: "18", name: "port_qspim0_sdio3", desc: "Connect port sdio3 from port group qspim0 to this pad." }
                      { value: "19", name: "port_qspis0_csn", desc: "Connect port csn from port group qspis0 to this pad." }
                      { value: "20", name: "port_qspis0_sck", desc: "Connect port sck from port group qspis0 to this pad." }
                      { value: "21", name: "port_qspis0_sdio0", desc: "Connect port sdio0 from port group qspis0 to this pad." }
                      { value: "22", name: "port_qspis0_sdio1", desc: "Connect port sdio1 from port group qspis0 to this pad." }
                      { value: "23", name: "port_qspis0_sdio2", desc: "Connect port sdio2 from port group qspis0 to this pad." }
                      { value: "24", name: "port_qspis0_sdio3", desc: "Connect port sdio3 from port group qspis0 to this pad." }
                      { value: "25", name: "port_uart0_rx", desc: "Connect port rx from port group uart0 to this pad." }
                      { value: "26", name: "port_uart0_tx", desc: "Connect port tx from port group uart0 to this pad." }
                  ]
              }
          ]
      }

      {
          name: PAD_GPIO04_CFG
          desc: '''
            Pad signal configuration.
          '''
          swaccess: "rw"
          fields: [
            {
                bits: "0"
                name: chip2pad
                desc: '''
                     Connects to pad's TX driver
                '''
                swaccess: "rw"
                hwaccess: "hro"
                resval: "0"
            },
            {
                bits: "1"
                name: drv0
                desc: '''
                     Choose the driving strength of the pad. LSB = ~3mA
                '''
                swaccess: "rw"
                hwaccess: "hro"
                resval: "0"
            },
            {
                bits: "2"
                name: drv1
                desc: '''
                     Choose the driving strength of the pad. LSB = ~3mA
                '''
                swaccess: "rw"
                hwaccess: "hro"
                resval: "0"
            },
            {
                bits: "3"
                name: drv2
                desc: '''
                     Choose the driving strength of the pad. LSB = ~3mA
                '''
                swaccess: "rw"
                hwaccess: "hro"
                resval: "0"
            },
            {
                bits: "4"
                name: drv3
                desc: '''
                     Choose the driving strength of the pad. LSB = ~3mA
                '''
                swaccess: "rw"
                hwaccess: "hro"
                resval: "1"
            },
            {
                bits: "5"
                name: pull_en
                desc: '''
                     Enable pull up/down (depends on pull_sel) resistor, active-high
                '''
                swaccess: "rw"
                hwaccess: "hro"
                resval: "0"
            },
            {
                bits: "6"
                name: pull_sel
                desc: '''
                     1 -> use pull-up resistor (if pull_en == 1), 0 -> use pull-down resistor
                '''
                swaccess: "rw"
                hwaccess: "hro"
                resval: "0"
            },
            {
                bits: "7"
                name: ret_en
                desc: '''
                     Enable retention mode, active-high
                '''
                swaccess: "rw"
                hwaccess: "hro"
                resval: "0"
            },
            {
                bits: "8"
                name: st_en
                desc: '''
                     Schmitt-trigger enable, active high
                '''
                swaccess: "rw"
                hwaccess: "hro"
                resval: "0"
            },
            {
                bits: "9"
                name: tx_en
                desc: '''
                     TX driver enable, active low
                '''
                swaccess: "rw"
                hwaccess: "hro"
                resval: "0"
            },
          ]
      }

       {
          name: PAD_GPIO04_MUX_SEL
          desc: '''
              Pad signal port multiplex selection for pad pad_gpio04. The programmed value defines which port
              is connected to the pad.
          '''
          swaccess: "rw"
          hwaccess: "hro"
          resval: 0
          fields: [
              {
                  bits: "4:0"
                  enum: [
                      { value: "0", name: "register", desc: "Connects the Pad to the internal configuration register."}
                      { value: "1", name: "port_gpio_gpio04", desc: "Connect port gpio04 from port group gpio to this pad." }
                      { value: "2", name: "port_i2c0_scl", desc: "Connect port scl from port group i2c0 to this pad." }
                      { value: "3", name: "port_i2c0_sda", desc: "Connect port sda from port group i2c0 to this pad." }
                      { value: "4", name: "port_i3c0_puc", desc: "Connect port puc from port group i3c0 to this pad." }
                      { value: "5", name: "port_i3c0_scl", desc: "Connect port scl from port group i3c0 to this pad." }
                      { value: "6", name: "port_i3c0_sda", desc: "Connect port sda from port group i3c0 to this pad." }
                      { value: "7", name: "port_i3c1_puc", desc: "Connect port puc from port group i3c1 to this pad." }
                      { value: "8", name: "port_i3c1_scl", desc: "Connect port scl from port group i3c1 to this pad." }
                      { value: "9", name: "port_i3c1_sda", desc: "Connect port sda from port group i3c1 to this pad." }
                      { value: "10", name: "port_qspim0_csn0", desc: "Connect port csn0 from port group qspim0 to this pad." }
                      { value: "11", name: "port_qspim0_csn1", desc: "Connect port csn1 from port group qspim0 to this pad." }
                      { value: "12", name: "port_qspim0_csn2", desc: "Connect port csn2 from port group qspim0 to this pad." }
                      { value: "13", name: "port_qspim0_csn3", desc: "Connect port csn3 from port group qspim0 to this pad." }
                      { value: "14", name: "port_qspim0_sck", desc: "Connect port sck from port group qspim0 to this pad." }
                      { value: "15", name: "port_qspim0_sdio0", desc: "Connect port sdio0 from port group qspim0 to this pad." }
                      { value: "16", name: "port_qspim0_sdio1", desc: "Connect port sdio1 from port group qspim0 to this pad." }
                      { value: "17", name: "port_qspim0_sdio2", desc: "Connect port sdio2 from port group qspim0 to this pad." }
                      { value: "18", name: "port_qspim0_sdio3", desc: "Connect port sdio3 from port group qspim0 to this pad." }
                      { value: "19", name: "port_qspis0_csn", desc: "Connect port csn from port group qspis0 to this pad." }
                      { value: "20", name: "port_qspis0_sck", desc: "Connect port sck from port group qspis0 to this pad." }
                      { value: "21", name: "port_qspis0_sdio0", desc: "Connect port sdio0 from port group qspis0 to this pad." }
                      { value: "22", name: "port_qspis0_sdio1", desc: "Connect port sdio1 from port group qspis0 to this pad." }
                      { value: "23", name: "port_qspis0_sdio2", desc: "Connect port sdio2 from port group qspis0 to this pad." }
                      { value: "24", name: "port_qspis0_sdio3", desc: "Connect port sdio3 from port group qspis0 to this pad." }
                      { value: "25", name: "port_uart0_rx", desc: "Connect port rx from port group uart0 to this pad." }
                      { value: "26", name: "port_uart0_tx", desc: "Connect port tx from port group uart0 to this pad." }
                  ]
              }
          ]
      }

      {
          name: PAD_GPIO05_CFG
          desc: '''
            Pad signal configuration.
          '''
          swaccess: "rw"
          fields: [
            {
                bits: "0"
                name: chip2pad
                desc: '''
                     Connects to pad's TX driver
                '''
                swaccess: "rw"
                hwaccess: "hro"
                resval: "0"
            },
            {
                bits: "1"
                name: drv0
                desc: '''
                     Choose the driving strength of the pad. LSB = ~3mA
                '''
                swaccess: "rw"
                hwaccess: "hro"
                resval: "0"
            },
            {
                bits: "2"
                name: drv1
                desc: '''
                     Choose the driving strength of the pad. LSB = ~3mA
                '''
                swaccess: "rw"
                hwaccess: "hro"
                resval: "0"
            },
            {
                bits: "3"
                name: drv2
                desc: '''
                     Choose the driving strength of the pad. LSB = ~3mA
                '''
                swaccess: "rw"
                hwaccess: "hro"
                resval: "0"
            },
            {
                bits: "4"
                name: drv3
                desc: '''
                     Choose the driving strength of the pad. LSB = ~3mA
                '''
                swaccess: "rw"
                hwaccess: "hro"
                resval: "1"
            },
            {
                bits: "5"
                name: pull_en
                desc: '''
                     Enable pull up/down (depends on pull_sel) resistor, active-high
                '''
                swaccess: "rw"
                hwaccess: "hro"
                resval: "0"
            },
            {
                bits: "6"
                name: pull_sel
                desc: '''
                     1 -> use pull-up resistor (if pull_en == 1), 0 -> use pull-down resistor
                '''
                swaccess: "rw"
                hwaccess: "hro"
                resval: "0"
            },
            {
                bits: "7"
                name: ret_en
                desc: '''
                     Enable retention mode, active-high
                '''
                swaccess: "rw"
                hwaccess: "hro"
                resval: "0"
            },
            {
                bits: "8"
                name: st_en
                desc: '''
                     Schmitt-trigger enable, active high
                '''
                swaccess: "rw"
                hwaccess: "hro"
                resval: "0"
            },
            {
                bits: "9"
                name: tx_en
                desc: '''
                     TX driver enable, active low
                '''
                swaccess: "rw"
                hwaccess: "hro"
                resval: "0"
            },
          ]
      }

       {
          name: PAD_GPIO05_MUX_SEL
          desc: '''
              Pad signal port multiplex selection for pad pad_gpio05. The programmed value defines which port
              is connected to the pad.
          '''
          swaccess: "rw"
          hwaccess: "hro"
          resval: 0
          fields: [
              {
                  bits: "4:0"
                  enum: [
                      { value: "0", name: "register", desc: "Connects the Pad to the internal configuration register."}
                      { value: "1", name: "port_gpio_gpio05", desc: "Connect port gpio05 from port group gpio to this pad." }
                      { value: "2", name: "port_i2c0_scl", desc: "Connect port scl from port group i2c0 to this pad." }
                      { value: "3", name: "port_i2c0_sda", desc: "Connect port sda from port group i2c0 to this pad." }
                      { value: "4", name: "port_i3c0_puc", desc: "Connect port puc from port group i3c0 to this pad." }
                      { value: "5", name: "port_i3c0_scl", desc: "Connect port scl from port group i3c0 to this pad." }
                      { value: "6", name: "port_i3c0_sda", desc: "Connect port sda from port group i3c0 to this pad." }
                      { value: "7", name: "port_i3c1_puc", desc: "Connect port puc from port group i3c1 to this pad." }
                      { value: "8", name: "port_i3c1_scl", desc: "Connect port scl from port group i3c1 to this pad." }
                      { value: "9", name: "port_i3c1_sda", desc: "Connect port sda from port group i3c1 to this pad." }
                      { value: "10", name: "port_qspim0_csn0", desc: "Connect port csn0 from port group qspim0 to this pad." }
                      { value: "11", name: "port_qspim0_csn1", desc: "Connect port csn1 from port group qspim0 to this pad." }
                      { value: "12", name: "port_qspim0_csn2", desc: "Connect port csn2 from port group qspim0 to this pad." }
                      { value: "13", name: "port_qspim0_csn3", desc: "Connect port csn3 from port group qspim0 to this pad." }
                      { value: "14", name: "port_qspim0_sck", desc: "Connect port sck from port group qspim0 to this pad." }
                      { value: "15", name: "port_qspim0_sdio0", desc: "Connect port sdio0 from port group qspim0 to this pad." }
                      { value: "16", name: "port_qspim0_sdio1", desc: "Connect port sdio1 from port group qspim0 to this pad." }
                      { value: "17", name: "port_qspim0_sdio2", desc: "Connect port sdio2 from port group qspim0 to this pad." }
                      { value: "18", name: "port_qspim0_sdio3", desc: "Connect port sdio3 from port group qspim0 to this pad." }
                      { value: "19", name: "port_qspis0_csn", desc: "Connect port csn from port group qspis0 to this pad." }
                      { value: "20", name: "port_qspis0_sck", desc: "Connect port sck from port group qspis0 to this pad." }
                      { value: "21", name: "port_qspis0_sdio0", desc: "Connect port sdio0 from port group qspis0 to this pad." }
                      { value: "22", name: "port_qspis0_sdio1", desc: "Connect port sdio1 from port group qspis0 to this pad." }
                      { value: "23", name: "port_qspis0_sdio2", desc: "Connect port sdio2 from port group qspis0 to this pad." }
                      { value: "24", name: "port_qspis0_sdio3", desc: "Connect port sdio3 from port group qspis0 to this pad." }
                      { value: "25", name: "port_uart0_rx", desc: "Connect port rx from port group uart0 to this pad." }
                      { value: "26", name: "port_uart0_tx", desc: "Connect port tx from port group uart0 to this pad." }
                  ]
              }
          ]
      }

      {
          name: PAD_GPIO06_CFG
          desc: '''
            Pad signal configuration.
          '''
          swaccess: "rw"
          fields: [
            {
                bits: "0"
                name: chip2pad
                desc: '''
                     Connects to pad's TX driver
                '''
                swaccess: "rw"
                hwaccess: "hro"
                resval: "0"
            },
            {
                bits: "1"
                name: drv0
                desc: '''
                     Choose the driving strength of the pad. LSB = ~3mA
                '''
                swaccess: "rw"
                hwaccess: "hro"
                resval: "0"
            },
            {
                bits: "2"
                name: drv1
                desc: '''
                     Choose the driving strength of the pad. LSB = ~3mA
                '''
                swaccess: "rw"
                hwaccess: "hro"
                resval: "0"
            },
            {
                bits: "3"
                name: drv2
                desc: '''
                     Choose the driving strength of the pad. LSB = ~3mA
                '''
                swaccess: "rw"
                hwaccess: "hro"
                resval: "0"
            },
            {
                bits: "4"
                name: drv3
                desc: '''
                     Choose the driving strength of the pad. LSB = ~3mA
                '''
                swaccess: "rw"
                hwaccess: "hro"
                resval: "1"
            },
            {
                bits: "5"
                name: pull_en
                desc: '''
                     Enable pull up/down (depends on pull_sel) resistor, active-high
                '''
                swaccess: "rw"
                hwaccess: "hro"
                resval: "0"
            },
            {
                bits: "6"
                name: pull_sel
                desc: '''
                     1 -> use pull-up resistor (if pull_en == 1), 0 -> use pull-down resistor
                '''
                swaccess: "rw"
                hwaccess: "hro"
                resval: "0"
            },
            {
                bits: "7"
                name: ret_en
                desc: '''
                     Enable retention mode, active-high
                '''
                swaccess: "rw"
                hwaccess: "hro"
                resval: "0"
            },
            {
                bits: "8"
                name: st_en
                desc: '''
                     Schmitt-trigger enable, active high
                '''
                swaccess: "rw"
                hwaccess: "hro"
                resval: "0"
            },
            {
                bits: "9"
                name: tx_en
                desc: '''
                     TX driver enable, active low
                '''
                swaccess: "rw"
                hwaccess: "hro"
                resval: "0"
            },
          ]
      }

       {
          name: PAD_GPIO06_MUX_SEL
          desc: '''
              Pad signal port multiplex selection for pad pad_gpio06. The programmed value defines which port
              is connected to the pad.
          '''
          swaccess: "rw"
          hwaccess: "hro"
          resval: 0
          fields: [
              {
                  bits: "4:0"
                  enum: [
                      { value: "0", name: "register", desc: "Connects the Pad to the internal configuration register."}
                      { value: "1", name: "port_gpio_gpio06", desc: "Connect port gpio06 from port group gpio to this pad." }
                      { value: "2", name: "port_i2c0_scl", desc: "Connect port scl from port group i2c0 to this pad." }
                      { value: "3", name: "port_i2c0_sda", desc: "Connect port sda from port group i2c0 to this pad." }
                      { value: "4", name: "port_i3c0_puc", desc: "Connect port puc from port group i3c0 to this pad." }
                      { value: "5", name: "port_i3c0_scl", desc: "Connect port scl from port group i3c0 to this pad." }
                      { value: "6", name: "port_i3c0_sda", desc: "Connect port sda from port group i3c0 to this pad." }
                      { value: "7", name: "port_i3c1_puc", desc: "Connect port puc from port group i3c1 to this pad." }
                      { value: "8", name: "port_i3c1_scl", desc: "Connect port scl from port group i3c1 to this pad." }
                      { value: "9", name: "port_i3c1_sda", desc: "Connect port sda from port group i3c1 to this pad." }
                      { value: "10", name: "port_qspim0_csn0", desc: "Connect port csn0 from port group qspim0 to this pad." }
                      { value: "11", name: "port_qspim0_csn1", desc: "Connect port csn1 from port group qspim0 to this pad." }
                      { value: "12", name: "port_qspim0_csn2", desc: "Connect port csn2 from port group qspim0 to this pad." }
                      { value: "13", name: "port_qspim0_csn3", desc: "Connect port csn3 from port group qspim0 to this pad." }
                      { value: "14", name: "port_qspim0_sck", desc: "Connect port sck from port group qspim0 to this pad." }
                      { value: "15", name: "port_qspim0_sdio0", desc: "Connect port sdio0 from port group qspim0 to this pad." }
                      { value: "16", name: "port_qspim0_sdio1", desc: "Connect port sdio1 from port group qspim0 to this pad." }
                      { value: "17", name: "port_qspim0_sdio2", desc: "Connect port sdio2 from port group qspim0 to this pad." }
                      { value: "18", name: "port_qspim0_sdio3", desc: "Connect port sdio3 from port group qspim0 to this pad." }
                      { value: "19", name: "port_qspis0_csn", desc: "Connect port csn from port group qspis0 to this pad." }
                      { value: "20", name: "port_qspis0_sck", desc: "Connect port sck from port group qspis0 to this pad." }
                      { value: "21", name: "port_qspis0_sdio0", desc: "Connect port sdio0 from port group qspis0 to this pad." }
                      { value: "22", name: "port_qspis0_sdio1", desc: "Connect port sdio1 from port group qspis0 to this pad." }
                      { value: "23", name: "port_qspis0_sdio2", desc: "Connect port sdio2 from port group qspis0 to this pad." }
                      { value: "24", name: "port_qspis0_sdio3", desc: "Connect port sdio3 from port group qspis0 to this pad." }
                      { value: "25", name: "port_uart0_rx", desc: "Connect port rx from port group uart0 to this pad." }
                      { value: "26", name: "port_uart0_tx", desc: "Connect port tx from port group uart0 to this pad." }
                  ]
              }
          ]
      }

      {
          name: PAD_GPIO07_CFG
          desc: '''
            Pad signal configuration.
          '''
          swaccess: "rw"
          fields: [
            {
                bits: "0"
                name: chip2pad
                desc: '''
                     Connects to pad's TX driver
                '''
                swaccess: "rw"
                hwaccess: "hro"
                resval: "0"
            },
            {
                bits: "1"
                name: drv0
                desc: '''
                     Choose the driving strength of the pad. LSB = ~3mA
                '''
                swaccess: "rw"
                hwaccess: "hro"
                resval: "0"
            },
            {
                bits: "2"
                name: drv1
                desc: '''
                     Choose the driving strength of the pad. LSB = ~3mA
                '''
                swaccess: "rw"
                hwaccess: "hro"
                resval: "0"
            },
            {
                bits: "3"
                name: drv2
                desc: '''
                     Choose the driving strength of the pad. LSB = ~3mA
                '''
                swaccess: "rw"
                hwaccess: "hro"
                resval: "0"
            },
            {
                bits: "4"
                name: drv3
                desc: '''
                     Choose the driving strength of the pad. LSB = ~3mA
                '''
                swaccess: "rw"
                hwaccess: "hro"
                resval: "1"
            },
            {
                bits: "5"
                name: pull_en
                desc: '''
                     Enable pull up/down (depends on pull_sel) resistor, active-high
                '''
                swaccess: "rw"
                hwaccess: "hro"
                resval: "0"
            },
            {
                bits: "6"
                name: pull_sel
                desc: '''
                     1 -> use pull-up resistor (if pull_en == 1), 0 -> use pull-down resistor
                '''
                swaccess: "rw"
                hwaccess: "hro"
                resval: "0"
            },
            {
                bits: "7"
                name: ret_en
                desc: '''
                     Enable retention mode, active-high
                '''
                swaccess: "rw"
                hwaccess: "hro"
                resval: "0"
            },
            {
                bits: "8"
                name: st_en
                desc: '''
                     Schmitt-trigger enable, active high
                '''
                swaccess: "rw"
                hwaccess: "hro"
                resval: "0"
            },
            {
                bits: "9"
                name: tx_en
                desc: '''
                     TX driver enable, active low
                '''
                swaccess: "rw"
                hwaccess: "hro"
                resval: "0"
            },
          ]
      }

       {
          name: PAD_GPIO07_MUX_SEL
          desc: '''
              Pad signal port multiplex selection for pad pad_gpio07. The programmed value defines which port
              is connected to the pad.
          '''
          swaccess: "rw"
          hwaccess: "hro"
          resval: 0
          fields: [
              {
                  bits: "4:0"
                  enum: [
                      { value: "0", name: "register", desc: "Connects the Pad to the internal configuration register."}
                      { value: "1", name: "port_gpio_gpio07", desc: "Connect port gpio07 from port group gpio to this pad." }
                      { value: "2", name: "port_i2c0_scl", desc: "Connect port scl from port group i2c0 to this pad." }
                      { value: "3", name: "port_i2c0_sda", desc: "Connect port sda from port group i2c0 to this pad." }
                      { value: "4", name: "port_i3c0_puc", desc: "Connect port puc from port group i3c0 to this pad." }
                      { value: "5", name: "port_i3c0_scl", desc: "Connect port scl from port group i3c0 to this pad." }
                      { value: "6", name: "port_i3c0_sda", desc: "Connect port sda from port group i3c0 to this pad." }
                      { value: "7", name: "port_i3c1_puc", desc: "Connect port puc from port group i3c1 to this pad." }
                      { value: "8", name: "port_i3c1_scl", desc: "Connect port scl from port group i3c1 to this pad." }
                      { value: "9", name: "port_i3c1_sda", desc: "Connect port sda from port group i3c1 to this pad." }
                      { value: "10", name: "port_qspim0_csn0", desc: "Connect port csn0 from port group qspim0 to this pad." }
                      { value: "11", name: "port_qspim0_csn1", desc: "Connect port csn1 from port group qspim0 to this pad." }
                      { value: "12", name: "port_qspim0_csn2", desc: "Connect port csn2 from port group qspim0 to this pad." }
                      { value: "13", name: "port_qspim0_csn3", desc: "Connect port csn3 from port group qspim0 to this pad." }
                      { value: "14", name: "port_qspim0_sck", desc: "Connect port sck from port group qspim0 to this pad." }
                      { value: "15", name: "port_qspim0_sdio0", desc: "Connect port sdio0 from port group qspim0 to this pad." }
                      { value: "16", name: "port_qspim0_sdio1", desc: "Connect port sdio1 from port group qspim0 to this pad." }
                      { value: "17", name: "port_qspim0_sdio2", desc: "Connect port sdio2 from port group qspim0 to this pad." }
                      { value: "18", name: "port_qspim0_sdio3", desc: "Connect port sdio3 from port group qspim0 to this pad." }
                      { value: "19", name: "port_qspis0_csn", desc: "Connect port csn from port group qspis0 to this pad." }
                      { value: "20", name: "port_qspis0_sck", desc: "Connect port sck from port group qspis0 to this pad." }
                      { value: "21", name: "port_qspis0_sdio0", desc: "Connect port sdio0 from port group qspis0 to this pad." }
                      { value: "22", name: "port_qspis0_sdio1", desc: "Connect port sdio1 from port group qspis0 to this pad." }
                      { value: "23", name: "port_qspis0_sdio2", desc: "Connect port sdio2 from port group qspis0 to this pad." }
                      { value: "24", name: "port_qspis0_sdio3", desc: "Connect port sdio3 from port group qspis0 to this pad." }
                      { value: "25", name: "port_uart0_rx", desc: "Connect port rx from port group uart0 to this pad." }
                      { value: "26", name: "port_uart0_tx", desc: "Connect port tx from port group uart0 to this pad." }
                  ]
              }
          ]
      }

      {
          name: PAD_GPIO08_CFG
          desc: '''
            Pad signal configuration.
          '''
          swaccess: "rw"
          fields: [
            {
                bits: "0"
                name: chip2pad
                desc: '''
                     Connects to pad's TX driver
                '''
                swaccess: "rw"
                hwaccess: "hro"
                resval: "0"
            },
            {
                bits: "1"
                name: drv0
                desc: '''
                     Choose the driving strength of the pad. LSB = ~3mA
                '''
                swaccess: "rw"
                hwaccess: "hro"
                resval: "0"
            },
            {
                bits: "2"
                name: drv1
                desc: '''
                     Choose the driving strength of the pad. LSB = ~3mA
                '''
                swaccess: "rw"
                hwaccess: "hro"
                resval: "0"
            },
            {
                bits: "3"
                name: drv2
                desc: '''
                     Choose the driving strength of the pad. LSB = ~3mA
                '''
                swaccess: "rw"
                hwaccess: "hro"
                resval: "0"
            },
            {
                bits: "4"
                name: drv3
                desc: '''
                     Choose the driving strength of the pad. LSB = ~3mA
                '''
                swaccess: "rw"
                hwaccess: "hro"
                resval: "1"
            },
            {
                bits: "5"
                name: pull_en
                desc: '''
                     Enable pull up/down (depends on pull_sel) resistor, active-high
                '''
                swaccess: "rw"
                hwaccess: "hro"
                resval: "0"
            },
            {
                bits: "6"
                name: pull_sel
                desc: '''
                     1 -> use pull-up resistor (if pull_en == 1), 0 -> use pull-down resistor
                '''
                swaccess: "rw"
                hwaccess: "hro"
                resval: "0"
            },
            {
                bits: "7"
                name: ret_en
                desc: '''
                     Enable retention mode, active-high
                '''
                swaccess: "rw"
                hwaccess: "hro"
                resval: "0"
            },
            {
                bits: "8"
                name: st_en
                desc: '''
                     Schmitt-trigger enable, active high
                '''
                swaccess: "rw"
                hwaccess: "hro"
                resval: "0"
            },
            {
                bits: "9"
                name: tx_en
                desc: '''
                     TX driver enable, active low
                '''
                swaccess: "rw"
                hwaccess: "hro"
                resval: "0"
            },
          ]
      }

       {
          name: PAD_GPIO08_MUX_SEL
          desc: '''
              Pad signal port multiplex selection for pad pad_gpio08. The programmed value defines which port
              is connected to the pad.
          '''
          swaccess: "rw"
          hwaccess: "hro"
          resval: 0
          fields: [
              {
                  bits: "4:0"
                  enum: [
                      { value: "0", name: "register", desc: "Connects the Pad to the internal configuration register."}
                      { value: "1", name: "port_gpio_gpio08", desc: "Connect port gpio08 from port group gpio to this pad." }
                      { value: "2", name: "port_i2c0_scl", desc: "Connect port scl from port group i2c0 to this pad." }
                      { value: "3", name: "port_i2c0_sda", desc: "Connect port sda from port group i2c0 to this pad." }
                      { value: "4", name: "port_i3c0_puc", desc: "Connect port puc from port group i3c0 to this pad." }
                      { value: "5", name: "port_i3c0_scl", desc: "Connect port scl from port group i3c0 to this pad." }
                      { value: "6", name: "port_i3c0_sda", desc: "Connect port sda from port group i3c0 to this pad." }
                      { value: "7", name: "port_i3c1_puc", desc: "Connect port puc from port group i3c1 to this pad." }
                      { value: "8", name: "port_i3c1_scl", desc: "Connect port scl from port group i3c1 to this pad." }
                      { value: "9", name: "port_i3c1_sda", desc: "Connect port sda from port group i3c1 to this pad." }
                      { value: "10", name: "port_qspim0_csn0", desc: "Connect port csn0 from port group qspim0 to this pad." }
                      { value: "11", name: "port_qspim0_csn1", desc: "Connect port csn1 from port group qspim0 to this pad." }
                      { value: "12", name: "port_qspim0_csn2", desc: "Connect port csn2 from port group qspim0 to this pad." }
                      { value: "13", name: "port_qspim0_csn3", desc: "Connect port csn3 from port group qspim0 to this pad." }
                      { value: "14", name: "port_qspim0_sck", desc: "Connect port sck from port group qspim0 to this pad." }
                      { value: "15", name: "port_qspim0_sdio0", desc: "Connect port sdio0 from port group qspim0 to this pad." }
                      { value: "16", name: "port_qspim0_sdio1", desc: "Connect port sdio1 from port group qspim0 to this pad." }
                      { value: "17", name: "port_qspim0_sdio2", desc: "Connect port sdio2 from port group qspim0 to this pad." }
                      { value: "18", name: "port_qspim0_sdio3", desc: "Connect port sdio3 from port group qspim0 to this pad." }
                      { value: "19", name: "port_qspis0_csn", desc: "Connect port csn from port group qspis0 to this pad." }
                      { value: "20", name: "port_qspis0_sck", desc: "Connect port sck from port group qspis0 to this pad." }
                      { value: "21", name: "port_qspis0_sdio0", desc: "Connect port sdio0 from port group qspis0 to this pad." }
                      { value: "22", name: "port_qspis0_sdio1", desc: "Connect port sdio1 from port group qspis0 to this pad." }
                      { value: "23", name: "port_qspis0_sdio2", desc: "Connect port sdio2 from port group qspis0 to this pad." }
                      { value: "24", name: "port_qspis0_sdio3", desc: "Connect port sdio3 from port group qspis0 to this pad." }
                      { value: "25", name: "port_uart0_rx", desc: "Connect port rx from port group uart0 to this pad." }
                      { value: "26", name: "port_uart0_tx", desc: "Connect port tx from port group uart0 to this pad." }
                  ]
              }
          ]
      }

      {
          name: PAD_GPIO09_CFG
          desc: '''
            Pad signal configuration.
          '''
          swaccess: "rw"
          fields: [
            {
                bits: "0"
                name: chip2pad
                desc: '''
                     Connects to pad's TX driver
                '''
                swaccess: "rw"
                hwaccess: "hro"
                resval: "0"
            },
            {
                bits: "1"
                name: drv0
                desc: '''
                     Choose the driving strength of the pad. LSB = ~3mA
                '''
                swaccess: "rw"
                hwaccess: "hro"
                resval: "0"
            },
            {
                bits: "2"
                name: drv1
                desc: '''
                     Choose the driving strength of the pad. LSB = ~3mA
                '''
                swaccess: "rw"
                hwaccess: "hro"
                resval: "0"
            },
            {
                bits: "3"
                name: drv2
                desc: '''
                     Choose the driving strength of the pad. LSB = ~3mA
                '''
                swaccess: "rw"
                hwaccess: "hro"
                resval: "0"
            },
            {
                bits: "4"
                name: drv3
                desc: '''
                     Choose the driving strength of the pad. LSB = ~3mA
                '''
                swaccess: "rw"
                hwaccess: "hro"
                resval: "1"
            },
            {
                bits: "5"
                name: pull_en
                desc: '''
                     Enable pull up/down (depends on pull_sel) resistor, active-high
                '''
                swaccess: "rw"
                hwaccess: "hro"
                resval: "0"
            },
            {
                bits: "6"
                name: pull_sel
                desc: '''
                     1 -> use pull-up resistor (if pull_en == 1), 0 -> use pull-down resistor
                '''
                swaccess: "rw"
                hwaccess: "hro"
                resval: "0"
            },
            {
                bits: "7"
                name: ret_en
                desc: '''
                     Enable retention mode, active-high
                '''
                swaccess: "rw"
                hwaccess: "hro"
                resval: "0"
            },
            {
                bits: "8"
                name: st_en
                desc: '''
                     Schmitt-trigger enable, active high
                '''
                swaccess: "rw"
                hwaccess: "hro"
                resval: "0"
            },
            {
                bits: "9"
                name: tx_en
                desc: '''
                     TX driver enable, active low
                '''
                swaccess: "rw"
                hwaccess: "hro"
                resval: "0"
            },
          ]
      }

       {
          name: PAD_GPIO09_MUX_SEL
          desc: '''
              Pad signal port multiplex selection for pad pad_gpio09. The programmed value defines which port
              is connected to the pad.
          '''
          swaccess: "rw"
          hwaccess: "hro"
          resval: 0
          fields: [
              {
                  bits: "4:0"
                  enum: [
                      { value: "0", name: "register", desc: "Connects the Pad to the internal configuration register."}
                      { value: "1", name: "port_gpio_gpio09", desc: "Connect port gpio09 from port group gpio to this pad." }
                      { value: "2", name: "port_i2c0_scl", desc: "Connect port scl from port group i2c0 to this pad." }
                      { value: "3", name: "port_i2c0_sda", desc: "Connect port sda from port group i2c0 to this pad." }
                      { value: "4", name: "port_i3c0_puc", desc: "Connect port puc from port group i3c0 to this pad." }
                      { value: "5", name: "port_i3c0_scl", desc: "Connect port scl from port group i3c0 to this pad." }
                      { value: "6", name: "port_i3c0_sda", desc: "Connect port sda from port group i3c0 to this pad." }
                      { value: "7", name: "port_i3c1_puc", desc: "Connect port puc from port group i3c1 to this pad." }
                      { value: "8", name: "port_i3c1_scl", desc: "Connect port scl from port group i3c1 to this pad." }
                      { value: "9", name: "port_i3c1_sda", desc: "Connect port sda from port group i3c1 to this pad." }
                      { value: "10", name: "port_qspim0_csn0", desc: "Connect port csn0 from port group qspim0 to this pad." }
                      { value: "11", name: "port_qspim0_csn1", desc: "Connect port csn1 from port group qspim0 to this pad." }
                      { value: "12", name: "port_qspim0_csn2", desc: "Connect port csn2 from port group qspim0 to this pad." }
                      { value: "13", name: "port_qspim0_csn3", desc: "Connect port csn3 from port group qspim0 to this pad." }
                      { value: "14", name: "port_qspim0_sck", desc: "Connect port sck from port group qspim0 to this pad." }
                      { value: "15", name: "port_qspim0_sdio0", desc: "Connect port sdio0 from port group qspim0 to this pad." }
                      { value: "16", name: "port_qspim0_sdio1", desc: "Connect port sdio1 from port group qspim0 to this pad." }
                      { value: "17", name: "port_qspim0_sdio2", desc: "Connect port sdio2 from port group qspim0 to this pad." }
                      { value: "18", name: "port_qspim0_sdio3", desc: "Connect port sdio3 from port group qspim0 to this pad." }
                      { value: "19", name: "port_qspis0_csn", desc: "Connect port csn from port group qspis0 to this pad." }
                      { value: "20", name: "port_qspis0_sck", desc: "Connect port sck from port group qspis0 to this pad." }
                      { value: "21", name: "port_qspis0_sdio0", desc: "Connect port sdio0 from port group qspis0 to this pad." }
                      { value: "22", name: "port_qspis0_sdio1", desc: "Connect port sdio1 from port group qspis0 to this pad." }
                      { value: "23", name: "port_qspis0_sdio2", desc: "Connect port sdio2 from port group qspis0 to this pad." }
                      { value: "24", name: "port_qspis0_sdio3", desc: "Connect port sdio3 from port group qspis0 to this pad." }
                      { value: "25", name: "port_uart0_rx", desc: "Connect port rx from port group uart0 to this pad." }
                      { value: "26", name: "port_uart0_tx", desc: "Connect port tx from port group uart0 to this pad." }
                  ]
              }
          ]
      }

      {
          name: PAD_GPIO10_CFG
          desc: '''
            Pad signal configuration.
          '''
          swaccess: "rw"
          fields: [
            {
                bits: "0"
                name: chip2pad
                desc: '''
                     Connects to pad's TX driver
                '''
                swaccess: "rw"
                hwaccess: "hro"
                resval: "0"
            },
            {
                bits: "1"
                name: drv0
                desc: '''
                     Choose the driving strength of the pad. LSB = ~3mA
                '''
                swaccess: "rw"
                hwaccess: "hro"
                resval: "0"
            },
            {
                bits: "2"
                name: drv1
                desc: '''
                     Choose the driving strength of the pad. LSB = ~3mA
                '''
                swaccess: "rw"
                hwaccess: "hro"
                resval: "0"
            },
            {
                bits: "3"
                name: drv2
                desc: '''
                     Choose the driving strength of the pad. LSB = ~3mA
                '''
                swaccess: "rw"
                hwaccess: "hro"
                resval: "0"
            },
            {
                bits: "4"
                name: drv3
                desc: '''
                     Choose the driving strength of the pad. LSB = ~3mA
                '''
                swaccess: "rw"
                hwaccess: "hro"
                resval: "1"
            },
            {
                bits: "5"
                name: pull_en
                desc: '''
                     Enable pull up/down (depends on pull_sel) resistor, active-high
                '''
                swaccess: "rw"
                hwaccess: "hro"
                resval: "0"
            },
            {
                bits: "6"
                name: pull_sel
                desc: '''
                     1 -> use pull-up resistor (if pull_en == 1), 0 -> use pull-down resistor
                '''
                swaccess: "rw"
                hwaccess: "hro"
                resval: "0"
            },
            {
                bits: "7"
                name: ret_en
                desc: '''
                     Enable retention mode, active-high
                '''
                swaccess: "rw"
                hwaccess: "hro"
                resval: "0"
            },
            {
                bits: "8"
                name: st_en
                desc: '''
                     Schmitt-trigger enable, active high
                '''
                swaccess: "rw"
                hwaccess: "hro"
                resval: "0"
            },
            {
                bits: "9"
                name: tx_en
                desc: '''
                     TX driver enable, active low
                '''
                swaccess: "rw"
                hwaccess: "hro"
                resval: "0"
            },
          ]
      }

       {
          name: PAD_GPIO10_MUX_SEL
          desc: '''
              Pad signal port multiplex selection for pad pad_gpio10. The programmed value defines which port
              is connected to the pad.
          '''
          swaccess: "rw"
          hwaccess: "hro"
          resval: 0
          fields: [
              {
                  bits: "4:0"
                  enum: [
                      { value: "0", name: "register", desc: "Connects the Pad to the internal configuration register."}
                      { value: "1", name: "port_gpio_gpio10", desc: "Connect port gpio10 from port group gpio to this pad." }
                      { value: "2", name: "port_i2c0_scl", desc: "Connect port scl from port group i2c0 to this pad." }
                      { value: "3", name: "port_i2c0_sda", desc: "Connect port sda from port group i2c0 to this pad." }
                      { value: "4", name: "port_i3c0_puc", desc: "Connect port puc from port group i3c0 to this pad." }
                      { value: "5", name: "port_i3c0_scl", desc: "Connect port scl from port group i3c0 to this pad." }
                      { value: "6", name: "port_i3c0_sda", desc: "Connect port sda from port group i3c0 to this pad." }
                      { value: "7", name: "port_i3c1_puc", desc: "Connect port puc from port group i3c1 to this pad." }
                      { value: "8", name: "port_i3c1_scl", desc: "Connect port scl from port group i3c1 to this pad." }
                      { value: "9", name: "port_i3c1_sda", desc: "Connect port sda from port group i3c1 to this pad." }
                      { value: "10", name: "port_qspim0_csn0", desc: "Connect port csn0 from port group qspim0 to this pad." }
                      { value: "11", name: "port_qspim0_csn1", desc: "Connect port csn1 from port group qspim0 to this pad." }
                      { value: "12", name: "port_qspim0_csn2", desc: "Connect port csn2 from port group qspim0 to this pad." }
                      { value: "13", name: "port_qspim0_csn3", desc: "Connect port csn3 from port group qspim0 to this pad." }
                      { value: "14", name: "port_qspim0_sck", desc: "Connect port sck from port group qspim0 to this pad." }
                      { value: "15", name: "port_qspim0_sdio0", desc: "Connect port sdio0 from port group qspim0 to this pad." }
                      { value: "16", name: "port_qspim0_sdio1", desc: "Connect port sdio1 from port group qspim0 to this pad." }
                      { value: "17", name: "port_qspim0_sdio2", desc: "Connect port sdio2 from port group qspim0 to this pad." }
                      { value: "18", name: "port_qspim0_sdio3", desc: "Connect port sdio3 from port group qspim0 to this pad." }
                      { value: "19", name: "port_qspis0_csn", desc: "Connect port csn from port group qspis0 to this pad." }
                      { value: "20", name: "port_qspis0_sck", desc: "Connect port sck from port group qspis0 to this pad." }
                      { value: "21", name: "port_qspis0_sdio0", desc: "Connect port sdio0 from port group qspis0 to this pad." }
                      { value: "22", name: "port_qspis0_sdio1", desc: "Connect port sdio1 from port group qspis0 to this pad." }
                      { value: "23", name: "port_qspis0_sdio2", desc: "Connect port sdio2 from port group qspis0 to this pad." }
                      { value: "24", name: "port_qspis0_sdio3", desc: "Connect port sdio3 from port group qspis0 to this pad." }
                      { value: "25", name: "port_uart0_rx", desc: "Connect port rx from port group uart0 to this pad." }
                      { value: "26", name: "port_uart0_tx", desc: "Connect port tx from port group uart0 to this pad." }
                  ]
              }
          ]
      }

      {
          name: PAD_GPIO11_CFG
          desc: '''
            Pad signal configuration.
          '''
          swaccess: "rw"
          fields: [
            {
                bits: "0"
                name: chip2pad
                desc: '''
                     Connects to pad's TX driver
                '''
                swaccess: "rw"
                hwaccess: "hro"
                resval: "0"
            },
            {
                bits: "1"
                name: drv0
                desc: '''
                     Choose the driving strength of the pad. LSB = ~3mA
                '''
                swaccess: "rw"
                hwaccess: "hro"
                resval: "0"
            },
            {
                bits: "2"
                name: drv1
                desc: '''
                     Choose the driving strength of the pad. LSB = ~3mA
                '''
                swaccess: "rw"
                hwaccess: "hro"
                resval: "0"
            },
            {
                bits: "3"
                name: drv2
                desc: '''
                     Choose the driving strength of the pad. LSB = ~3mA
                '''
                swaccess: "rw"
                hwaccess: "hro"
                resval: "0"
            },
            {
                bits: "4"
                name: drv3
                desc: '''
                     Choose the driving strength of the pad. LSB = ~3mA
                '''
                swaccess: "rw"
                hwaccess: "hro"
                resval: "1"
            },
            {
                bits: "5"
                name: pull_en
                desc: '''
                     Enable pull up/down (depends on pull_sel) resistor, active-high
                '''
                swaccess: "rw"
                hwaccess: "hro"
                resval: "0"
            },
            {
                bits: "6"
                name: pull_sel
                desc: '''
                     1 -> use pull-up resistor (if pull_en == 1), 0 -> use pull-down resistor
                '''
                swaccess: "rw"
                hwaccess: "hro"
                resval: "0"
            },
            {
                bits: "7"
                name: ret_en
                desc: '''
                     Enable retention mode, active-high
                '''
                swaccess: "rw"
                hwaccess: "hro"
                resval: "0"
            },
            {
                bits: "8"
                name: st_en
                desc: '''
                     Schmitt-trigger enable, active high
                '''
                swaccess: "rw"
                hwaccess: "hro"
                resval: "0"
            },
            {
                bits: "9"
                name: tx_en
                desc: '''
                     TX driver enable, active low
                '''
                swaccess: "rw"
                hwaccess: "hro"
                resval: "0"
            },
          ]
      }

       {
          name: PAD_GPIO11_MUX_SEL
          desc: '''
              Pad signal port multiplex selection for pad pad_gpio11. The programmed value defines which port
              is connected to the pad.
          '''
          swaccess: "rw"
          hwaccess: "hro"
          resval: 0
          fields: [
              {
                  bits: "4:0"
                  enum: [
                      { value: "0", name: "register", desc: "Connects the Pad to the internal configuration register."}
                      { value: "1", name: "port_gpio_gpio11", desc: "Connect port gpio11 from port group gpio to this pad." }
                      { value: "2", name: "port_i2c0_scl", desc: "Connect port scl from port group i2c0 to this pad." }
                      { value: "3", name: "port_i2c0_sda", desc: "Connect port sda from port group i2c0 to this pad." }
                      { value: "4", name: "port_i3c0_puc", desc: "Connect port puc from port group i3c0 to this pad." }
                      { value: "5", name: "port_i3c0_scl", desc: "Connect port scl from port group i3c0 to this pad." }
                      { value: "6", name: "port_i3c0_sda", desc: "Connect port sda from port group i3c0 to this pad." }
                      { value: "7", name: "port_i3c1_puc", desc: "Connect port puc from port group i3c1 to this pad." }
                      { value: "8", name: "port_i3c1_scl", desc: "Connect port scl from port group i3c1 to this pad." }
                      { value: "9", name: "port_i3c1_sda", desc: "Connect port sda from port group i3c1 to this pad." }
                      { value: "10", name: "port_qspim0_csn0", desc: "Connect port csn0 from port group qspim0 to this pad." }
                      { value: "11", name: "port_qspim0_csn1", desc: "Connect port csn1 from port group qspim0 to this pad." }
                      { value: "12", name: "port_qspim0_csn2", desc: "Connect port csn2 from port group qspim0 to this pad." }
                      { value: "13", name: "port_qspim0_csn3", desc: "Connect port csn3 from port group qspim0 to this pad." }
                      { value: "14", name: "port_qspim0_sck", desc: "Connect port sck from port group qspim0 to this pad." }
                      { value: "15", name: "port_qspim0_sdio0", desc: "Connect port sdio0 from port group qspim0 to this pad." }
                      { value: "16", name: "port_qspim0_sdio1", desc: "Connect port sdio1 from port group qspim0 to this pad." }
                      { value: "17", name: "port_qspim0_sdio2", desc: "Connect port sdio2 from port group qspim0 to this pad." }
                      { value: "18", name: "port_qspim0_sdio3", desc: "Connect port sdio3 from port group qspim0 to this pad." }
                      { value: "19", name: "port_qspis0_csn", desc: "Connect port csn from port group qspis0 to this pad." }
                      { value: "20", name: "port_qspis0_sck", desc: "Connect port sck from port group qspis0 to this pad." }
                      { value: "21", name: "port_qspis0_sdio0", desc: "Connect port sdio0 from port group qspis0 to this pad." }
                      { value: "22", name: "port_qspis0_sdio1", desc: "Connect port sdio1 from port group qspis0 to this pad." }
                      { value: "23", name: "port_qspis0_sdio2", desc: "Connect port sdio2 from port group qspis0 to this pad." }
                      { value: "24", name: "port_qspis0_sdio3", desc: "Connect port sdio3 from port group qspis0 to this pad." }
                      { value: "25", name: "port_uart0_rx", desc: "Connect port rx from port group uart0 to this pad." }
                      { value: "26", name: "port_uart0_tx", desc: "Connect port tx from port group uart0 to this pad." }
                  ]
              }
          ]
      }

      {
          name: PAD_GPIO12_CFG
          desc: '''
            Pad signal configuration.
          '''
          swaccess: "rw"
          fields: [
            {
                bits: "0"
                name: chip2pad
                desc: '''
                     Connects to pad's TX driver
                '''
                swaccess: "rw"
                hwaccess: "hro"
                resval: "0"
            },
            {
                bits: "1"
                name: drv0
                desc: '''
                     Choose the driving strength of the pad. LSB = ~3mA
                '''
                swaccess: "rw"
                hwaccess: "hro"
                resval: "0"
            },
            {
                bits: "2"
                name: drv1
                desc: '''
                     Choose the driving strength of the pad. LSB = ~3mA
                '''
                swaccess: "rw"
                hwaccess: "hro"
                resval: "0"
            },
            {
                bits: "3"
                name: drv2
                desc: '''
                     Choose the driving strength of the pad. LSB = ~3mA
                '''
                swaccess: "rw"
                hwaccess: "hro"
                resval: "0"
            },
            {
                bits: "4"
                name: drv3
                desc: '''
                     Choose the driving strength of the pad. LSB = ~3mA
                '''
                swaccess: "rw"
                hwaccess: "hro"
                resval: "1"
            },
            {
                bits: "5"
                name: pull_en
                desc: '''
                     Enable pull up/down (depends on pull_sel) resistor, active-high
                '''
                swaccess: "rw"
                hwaccess: "hro"
                resval: "0"
            },
            {
                bits: "6"
                name: pull_sel
                desc: '''
                     1 -> use pull-up resistor (if pull_en == 1), 0 -> use pull-down resistor
                '''
                swaccess: "rw"
                hwaccess: "hro"
                resval: "0"
            },
            {
                bits: "7"
                name: ret_en
                desc: '''
                     Enable retention mode, active-high
                '''
                swaccess: "rw"
                hwaccess: "hro"
                resval: "0"
            },
            {
                bits: "8"
                name: st_en
                desc: '''
                     Schmitt-trigger enable, active high
                '''
                swaccess: "rw"
                hwaccess: "hro"
                resval: "0"
            },
            {
                bits: "9"
                name: tx_en
                desc: '''
                     TX driver enable, active low
                '''
                swaccess: "rw"
                hwaccess: "hro"
                resval: "0"
            },
          ]
      }

       {
          name: PAD_GPIO12_MUX_SEL
          desc: '''
              Pad signal port multiplex selection for pad pad_gpio12. The programmed value defines which port
              is connected to the pad.
          '''
          swaccess: "rw"
          hwaccess: "hro"
          resval: 0
          fields: [
              {
                  bits: "4:0"
                  enum: [
                      { value: "0", name: "register", desc: "Connects the Pad to the internal configuration register."}
                      { value: "1", name: "port_gpio_gpio12", desc: "Connect port gpio12 from port group gpio to this pad." }
                      { value: "2", name: "port_i2c0_scl", desc: "Connect port scl from port group i2c0 to this pad." }
                      { value: "3", name: "port_i2c0_sda", desc: "Connect port sda from port group i2c0 to this pad." }
                      { value: "4", name: "port_i3c0_puc", desc: "Connect port puc from port group i3c0 to this pad." }
                      { value: "5", name: "port_i3c0_scl", desc: "Connect port scl from port group i3c0 to this pad." }
                      { value: "6", name: "port_i3c0_sda", desc: "Connect port sda from port group i3c0 to this pad." }
                      { value: "7", name: "port_i3c1_puc", desc: "Connect port puc from port group i3c1 to this pad." }
                      { value: "8", name: "port_i3c1_scl", desc: "Connect port scl from port group i3c1 to this pad." }
                      { value: "9", name: "port_i3c1_sda", desc: "Connect port sda from port group i3c1 to this pad." }
                      { value: "10", name: "port_qspim0_csn0", desc: "Connect port csn0 from port group qspim0 to this pad." }
                      { value: "11", name: "port_qspim0_csn1", desc: "Connect port csn1 from port group qspim0 to this pad." }
                      { value: "12", name: "port_qspim0_csn2", desc: "Connect port csn2 from port group qspim0 to this pad." }
                      { value: "13", name: "port_qspim0_csn3", desc: "Connect port csn3 from port group qspim0 to this pad." }
                      { value: "14", name: "port_qspim0_sck", desc: "Connect port sck from port group qspim0 to this pad." }
                      { value: "15", name: "port_qspim0_sdio0", desc: "Connect port sdio0 from port group qspim0 to this pad." }
                      { value: "16", name: "port_qspim0_sdio1", desc: "Connect port sdio1 from port group qspim0 to this pad." }
                      { value: "17", name: "port_qspim0_sdio2", desc: "Connect port sdio2 from port group qspim0 to this pad." }
                      { value: "18", name: "port_qspim0_sdio3", desc: "Connect port sdio3 from port group qspim0 to this pad." }
                      { value: "19", name: "port_qspis0_csn", desc: "Connect port csn from port group qspis0 to this pad." }
                      { value: "20", name: "port_qspis0_sck", desc: "Connect port sck from port group qspis0 to this pad." }
                      { value: "21", name: "port_qspis0_sdio0", desc: "Connect port sdio0 from port group qspis0 to this pad." }
                      { value: "22", name: "port_qspis0_sdio1", desc: "Connect port sdio1 from port group qspis0 to this pad." }
                      { value: "23", name: "port_qspis0_sdio2", desc: "Connect port sdio2 from port group qspis0 to this pad." }
                      { value: "24", name: "port_qspis0_sdio3", desc: "Connect port sdio3 from port group qspis0 to this pad." }
                      { value: "25", name: "port_uart0_rx", desc: "Connect port rx from port group uart0 to this pad." }
                      { value: "26", name: "port_uart0_tx", desc: "Connect port tx from port group uart0 to this pad." }
                  ]
              }
          ]
      }

      {
          name: PAD_GPIO13_CFG
          desc: '''
            Pad signal configuration.
          '''
          swaccess: "rw"
          fields: [
            {
                bits: "0"
                name: chip2pad
                desc: '''
                     Connects to pad's TX driver
                '''
                swaccess: "rw"
                hwaccess: "hro"
                resval: "0"
            },
            {
                bits: "1"
                name: drv0
                desc: '''
                     Choose the driving strength of the pad. LSB = ~3mA
                '''
                swaccess: "rw"
                hwaccess: "hro"
                resval: "0"
            },
            {
                bits: "2"
                name: drv1
                desc: '''
                     Choose the driving strength of the pad. LSB = ~3mA
                '''
                swaccess: "rw"
                hwaccess: "hro"
                resval: "0"
            },
            {
                bits: "3"
                name: drv2
                desc: '''
                     Choose the driving strength of the pad. LSB = ~3mA
                '''
                swaccess: "rw"
                hwaccess: "hro"
                resval: "0"
            },
            {
                bits: "4"
                name: drv3
                desc: '''
                     Choose the driving strength of the pad. LSB = ~3mA
                '''
                swaccess: "rw"
                hwaccess: "hro"
                resval: "1"
            },
            {
                bits: "5"
                name: pull_en
                desc: '''
                     Enable pull up/down (depends on pull_sel) resistor, active-high
                '''
                swaccess: "rw"
                hwaccess: "hro"
                resval: "0"
            },
            {
                bits: "6"
                name: pull_sel
                desc: '''
                     1 -> use pull-up resistor (if pull_en == 1), 0 -> use pull-down resistor
                '''
                swaccess: "rw"
                hwaccess: "hro"
                resval: "0"
            },
            {
                bits: "7"
                name: ret_en
                desc: '''
                     Enable retention mode, active-high
                '''
                swaccess: "rw"
                hwaccess: "hro"
                resval: "0"
            },
            {
                bits: "8"
                name: st_en
                desc: '''
                     Schmitt-trigger enable, active high
                '''
                swaccess: "rw"
                hwaccess: "hro"
                resval: "0"
            },
            {
                bits: "9"
                name: tx_en
                desc: '''
                     TX driver enable, active low
                '''
                swaccess: "rw"
                hwaccess: "hro"
                resval: "0"
            },
          ]
      }

       {
          name: PAD_GPIO13_MUX_SEL
          desc: '''
              Pad signal port multiplex selection for pad pad_gpio13. The programmed value defines which port
              is connected to the pad.
          '''
          swaccess: "rw"
          hwaccess: "hro"
          resval: 0
          fields: [
              {
                  bits: "4:0"
                  enum: [
                      { value: "0", name: "register", desc: "Connects the Pad to the internal configuration register."}
                      { value: "1", name: "port_gpio_gpio13", desc: "Connect port gpio13 from port group gpio to this pad." }
                      { value: "2", name: "port_i2c0_scl", desc: "Connect port scl from port group i2c0 to this pad." }
                      { value: "3", name: "port_i2c0_sda", desc: "Connect port sda from port group i2c0 to this pad." }
                      { value: "4", name: "port_i3c0_puc", desc: "Connect port puc from port group i3c0 to this pad." }
                      { value: "5", name: "port_i3c0_scl", desc: "Connect port scl from port group i3c0 to this pad." }
                      { value: "6", name: "port_i3c0_sda", desc: "Connect port sda from port group i3c0 to this pad." }
                      { value: "7", name: "port_i3c1_puc", desc: "Connect port puc from port group i3c1 to this pad." }
                      { value: "8", name: "port_i3c1_scl", desc: "Connect port scl from port group i3c1 to this pad." }
                      { value: "9", name: "port_i3c1_sda", desc: "Connect port sda from port group i3c1 to this pad." }
                      { value: "10", name: "port_qspim0_csn0", desc: "Connect port csn0 from port group qspim0 to this pad." }
                      { value: "11", name: "port_qspim0_csn1", desc: "Connect port csn1 from port group qspim0 to this pad." }
                      { value: "12", name: "port_qspim0_csn2", desc: "Connect port csn2 from port group qspim0 to this pad." }
                      { value: "13", name: "port_qspim0_csn3", desc: "Connect port csn3 from port group qspim0 to this pad." }
                      { value: "14", name: "port_qspim0_sck", desc: "Connect port sck from port group qspim0 to this pad." }
                      { value: "15", name: "port_qspim0_sdio0", desc: "Connect port sdio0 from port group qspim0 to this pad." }
                      { value: "16", name: "port_qspim0_sdio1", desc: "Connect port sdio1 from port group qspim0 to this pad." }
                      { value: "17", name: "port_qspim0_sdio2", desc: "Connect port sdio2 from port group qspim0 to this pad." }
                      { value: "18", name: "port_qspim0_sdio3", desc: "Connect port sdio3 from port group qspim0 to this pad." }
                      { value: "19", name: "port_qspis0_csn", desc: "Connect port csn from port group qspis0 to this pad." }
                      { value: "20", name: "port_qspis0_sck", desc: "Connect port sck from port group qspis0 to this pad." }
                      { value: "21", name: "port_qspis0_sdio0", desc: "Connect port sdio0 from port group qspis0 to this pad." }
                      { value: "22", name: "port_qspis0_sdio1", desc: "Connect port sdio1 from port group qspis0 to this pad." }
                      { value: "23", name: "port_qspis0_sdio2", desc: "Connect port sdio2 from port group qspis0 to this pad." }
                      { value: "24", name: "port_qspis0_sdio3", desc: "Connect port sdio3 from port group qspis0 to this pad." }
                      { value: "25", name: "port_uart0_rx", desc: "Connect port rx from port group uart0 to this pad." }
                      { value: "26", name: "port_uart0_tx", desc: "Connect port tx from port group uart0 to this pad." }
                  ]
              }
          ]
      }

      {
          name: PAD_GPIO14_CFG
          desc: '''
            Pad signal configuration.
          '''
          swaccess: "rw"
          fields: [
            {
                bits: "0"
                name: chip2pad
                desc: '''
                     Connects to pad's TX driver
                '''
                swaccess: "rw"
                hwaccess: "hro"
                resval: "0"
            },
            {
                bits: "1"
                name: drv0
                desc: '''
                     Choose the driving strength of the pad. LSB = ~3mA
                '''
                swaccess: "rw"
                hwaccess: "hro"
                resval: "0"
            },
            {
                bits: "2"
                name: drv1
                desc: '''
                     Choose the driving strength of the pad. LSB = ~3mA
                '''
                swaccess: "rw"
                hwaccess: "hro"
                resval: "0"
            },
            {
                bits: "3"
                name: drv2
                desc: '''
                     Choose the driving strength of the pad. LSB = ~3mA
                '''
                swaccess: "rw"
                hwaccess: "hro"
                resval: "0"
            },
            {
                bits: "4"
                name: drv3
                desc: '''
                     Choose the driving strength of the pad. LSB = ~3mA
                '''
                swaccess: "rw"
                hwaccess: "hro"
                resval: "1"
            },
            {
                bits: "5"
                name: pull_en
                desc: '''
                     Enable pull up/down (depends on pull_sel) resistor, active-high
                '''
                swaccess: "rw"
                hwaccess: "hro"
                resval: "0"
            },
            {
                bits: "6"
                name: pull_sel
                desc: '''
                     1 -> use pull-up resistor (if pull_en == 1), 0 -> use pull-down resistor
                '''
                swaccess: "rw"
                hwaccess: "hro"
                resval: "0"
            },
            {
                bits: "7"
                name: ret_en
                desc: '''
                     Enable retention mode, active-high
                '''
                swaccess: "rw"
                hwaccess: "hro"
                resval: "0"
            },
            {
                bits: "8"
                name: st_en
                desc: '''
                     Schmitt-trigger enable, active high
                '''
                swaccess: "rw"
                hwaccess: "hro"
                resval: "0"
            },
            {
                bits: "9"
                name: tx_en
                desc: '''
                     TX driver enable, active low
                '''
                swaccess: "rw"
                hwaccess: "hro"
                resval: "0"
            },
          ]
      }

       {
          name: PAD_GPIO14_MUX_SEL
          desc: '''
              Pad signal port multiplex selection for pad pad_gpio14. The programmed value defines which port
              is connected to the pad.
          '''
          swaccess: "rw"
          hwaccess: "hro"
          resval: 0
          fields: [
              {
                  bits: "4:0"
                  enum: [
                      { value: "0", name: "register", desc: "Connects the Pad to the internal configuration register."}
                      { value: "1", name: "port_gpio_gpio14", desc: "Connect port gpio14 from port group gpio to this pad." }
                      { value: "2", name: "port_i2c0_scl", desc: "Connect port scl from port group i2c0 to this pad." }
                      { value: "3", name: "port_i2c0_sda", desc: "Connect port sda from port group i2c0 to this pad." }
                      { value: "4", name: "port_i3c0_puc", desc: "Connect port puc from port group i3c0 to this pad." }
                      { value: "5", name: "port_i3c0_scl", desc: "Connect port scl from port group i3c0 to this pad." }
                      { value: "6", name: "port_i3c0_sda", desc: "Connect port sda from port group i3c0 to this pad." }
                      { value: "7", name: "port_i3c1_puc", desc: "Connect port puc from port group i3c1 to this pad." }
                      { value: "8", name: "port_i3c1_scl", desc: "Connect port scl from port group i3c1 to this pad." }
                      { value: "9", name: "port_i3c1_sda", desc: "Connect port sda from port group i3c1 to this pad." }
                      { value: "10", name: "port_qspim0_csn0", desc: "Connect port csn0 from port group qspim0 to this pad." }
                      { value: "11", name: "port_qspim0_csn1", desc: "Connect port csn1 from port group qspim0 to this pad." }
                      { value: "12", name: "port_qspim0_csn2", desc: "Connect port csn2 from port group qspim0 to this pad." }
                      { value: "13", name: "port_qspim0_csn3", desc: "Connect port csn3 from port group qspim0 to this pad." }
                      { value: "14", name: "port_qspim0_sck", desc: "Connect port sck from port group qspim0 to this pad." }
                      { value: "15", name: "port_qspim0_sdio0", desc: "Connect port sdio0 from port group qspim0 to this pad." }
                      { value: "16", name: "port_qspim0_sdio1", desc: "Connect port sdio1 from port group qspim0 to this pad." }
                      { value: "17", name: "port_qspim0_sdio2", desc: "Connect port sdio2 from port group qspim0 to this pad." }
                      { value: "18", name: "port_qspim0_sdio3", desc: "Connect port sdio3 from port group qspim0 to this pad." }
                      { value: "19", name: "port_qspis0_csn", desc: "Connect port csn from port group qspis0 to this pad." }
                      { value: "20", name: "port_qspis0_sck", desc: "Connect port sck from port group qspis0 to this pad." }
                      { value: "21", name: "port_qspis0_sdio0", desc: "Connect port sdio0 from port group qspis0 to this pad." }
                      { value: "22", name: "port_qspis0_sdio1", desc: "Connect port sdio1 from port group qspis0 to this pad." }
                      { value: "23", name: "port_qspis0_sdio2", desc: "Connect port sdio2 from port group qspis0 to this pad." }
                      { value: "24", name: "port_qspis0_sdio3", desc: "Connect port sdio3 from port group qspis0 to this pad." }
                      { value: "25", name: "port_uart0_rx", desc: "Connect port rx from port group uart0 to this pad." }
                      { value: "26", name: "port_uart0_tx", desc: "Connect port tx from port group uart0 to this pad." }
                  ]
              }
          ]
      }

      {
          name: PAD_GPIO15_CFG
          desc: '''
            Pad signal configuration.
          '''
          swaccess: "rw"
          fields: [
            {
                bits: "0"
                name: chip2pad
                desc: '''
                     Connects to pad's TX driver
                '''
                swaccess: "rw"
                hwaccess: "hro"
                resval: "0"
            },
            {
                bits: "1"
                name: drv0
                desc: '''
                     Choose the driving strength of the pad. LSB = ~3mA
                '''
                swaccess: "rw"
                hwaccess: "hro"
                resval: "0"
            },
            {
                bits: "2"
                name: drv1
                desc: '''
                     Choose the driving strength of the pad. LSB = ~3mA
                '''
                swaccess: "rw"
                hwaccess: "hro"
                resval: "0"
            },
            {
                bits: "3"
                name: drv2
                desc: '''
                     Choose the driving strength of the pad. LSB = ~3mA
                '''
                swaccess: "rw"
                hwaccess: "hro"
                resval: "0"
            },
            {
                bits: "4"
                name: drv3
                desc: '''
                     Choose the driving strength of the pad. LSB = ~3mA
                '''
                swaccess: "rw"
                hwaccess: "hro"
                resval: "1"
            },
            {
                bits: "5"
                name: pull_en
                desc: '''
                     Enable pull up/down (depends on pull_sel) resistor, active-high
                '''
                swaccess: "rw"
                hwaccess: "hro"
                resval: "0"
            },
            {
                bits: "6"
                name: pull_sel
                desc: '''
                     1 -> use pull-up resistor (if pull_en == 1), 0 -> use pull-down resistor
                '''
                swaccess: "rw"
                hwaccess: "hro"
                resval: "0"
            },
            {
                bits: "7"
                name: ret_en
                desc: '''
                     Enable retention mode, active-high
                '''
                swaccess: "rw"
                hwaccess: "hro"
                resval: "0"
            },
            {
                bits: "8"
                name: st_en
                desc: '''
                     Schmitt-trigger enable, active high
                '''
                swaccess: "rw"
                hwaccess: "hro"
                resval: "0"
            },
            {
                bits: "9"
                name: tx_en
                desc: '''
                     TX driver enable, active low
                '''
                swaccess: "rw"
                hwaccess: "hro"
                resval: "0"
            },
          ]
      }

       {
          name: PAD_GPIO15_MUX_SEL
          desc: '''
              Pad signal port multiplex selection for pad pad_gpio15. The programmed value defines which port
              is connected to the pad.
          '''
          swaccess: "rw"
          hwaccess: "hro"
          resval: 0
          fields: [
              {
                  bits: "4:0"
                  enum: [
                      { value: "0", name: "register", desc: "Connects the Pad to the internal configuration register."}
                      { value: "1", name: "port_gpio_gpio15", desc: "Connect port gpio15 from port group gpio to this pad." }
                      { value: "2", name: "port_i2c0_scl", desc: "Connect port scl from port group i2c0 to this pad." }
                      { value: "3", name: "port_i2c0_sda", desc: "Connect port sda from port group i2c0 to this pad." }
                      { value: "4", name: "port_i3c0_puc", desc: "Connect port puc from port group i3c0 to this pad." }
                      { value: "5", name: "port_i3c0_scl", desc: "Connect port scl from port group i3c0 to this pad." }
                      { value: "6", name: "port_i3c0_sda", desc: "Connect port sda from port group i3c0 to this pad." }
                      { value: "7", name: "port_i3c1_puc", desc: "Connect port puc from port group i3c1 to this pad." }
                      { value: "8", name: "port_i3c1_scl", desc: "Connect port scl from port group i3c1 to this pad." }
                      { value: "9", name: "port_i3c1_sda", desc: "Connect port sda from port group i3c1 to this pad." }
                      { value: "10", name: "port_qspim0_csn0", desc: "Connect port csn0 from port group qspim0 to this pad." }
                      { value: "11", name: "port_qspim0_csn1", desc: "Connect port csn1 from port group qspim0 to this pad." }
                      { value: "12", name: "port_qspim0_csn2", desc: "Connect port csn2 from port group qspim0 to this pad." }
                      { value: "13", name: "port_qspim0_csn3", desc: "Connect port csn3 from port group qspim0 to this pad." }
                      { value: "14", name: "port_qspim0_sck", desc: "Connect port sck from port group qspim0 to this pad." }
                      { value: "15", name: "port_qspim0_sdio0", desc: "Connect port sdio0 from port group qspim0 to this pad." }
                      { value: "16", name: "port_qspim0_sdio1", desc: "Connect port sdio1 from port group qspim0 to this pad." }
                      { value: "17", name: "port_qspim0_sdio2", desc: "Connect port sdio2 from port group qspim0 to this pad." }
                      { value: "18", name: "port_qspim0_sdio3", desc: "Connect port sdio3 from port group qspim0 to this pad." }
                      { value: "19", name: "port_qspis0_csn", desc: "Connect port csn from port group qspis0 to this pad." }
                      { value: "20", name: "port_qspis0_sck", desc: "Connect port sck from port group qspis0 to this pad." }
                      { value: "21", name: "port_qspis0_sdio0", desc: "Connect port sdio0 from port group qspis0 to this pad." }
                      { value: "22", name: "port_qspis0_sdio1", desc: "Connect port sdio1 from port group qspis0 to this pad." }
                      { value: "23", name: "port_qspis0_sdio2", desc: "Connect port sdio2 from port group qspis0 to this pad." }
                      { value: "24", name: "port_qspis0_sdio3", desc: "Connect port sdio3 from port group qspis0 to this pad." }
                      { value: "25", name: "port_uart0_rx", desc: "Connect port rx from port group uart0 to this pad." }
                      { value: "26", name: "port_uart0_tx", desc: "Connect port tx from port group uart0 to this pad." }
                  ]
              }
          ]
      }

      {
          name: PAD_GPIO16_CFG
          desc: '''
            Pad signal configuration.
          '''
          swaccess: "rw"
          fields: [
            {
                bits: "0"
                name: chip2pad
                desc: '''
                     Connects to pad's TX driver
                '''
                swaccess: "rw"
                hwaccess: "hro"
                resval: "0"
            },
            {
                bits: "1"
                name: drv0
                desc: '''
                     Choose the driving strength of the pad. LSB = ~3mA
                '''
                swaccess: "rw"
                hwaccess: "hro"
                resval: "0"
            },
            {
                bits: "2"
                name: drv1
                desc: '''
                     Choose the driving strength of the pad. LSB = ~3mA
                '''
                swaccess: "rw"
                hwaccess: "hro"
                resval: "0"
            },
            {
                bits: "3"
                name: drv2
                desc: '''
                     Choose the driving strength of the pad. LSB = ~3mA
                '''
                swaccess: "rw"
                hwaccess: "hro"
                resval: "0"
            },
            {
                bits: "4"
                name: drv3
                desc: '''
                     Choose the driving strength of the pad. LSB = ~3mA
                '''
                swaccess: "rw"
                hwaccess: "hro"
                resval: "1"
            },
            {
                bits: "5"
                name: pull_en
                desc: '''
                     Enable pull up/down (depends on pull_sel) resistor, active-high
                '''
                swaccess: "rw"
                hwaccess: "hro"
                resval: "0"
            },
            {
                bits: "6"
                name: pull_sel
                desc: '''
                     1 -> use pull-up resistor (if pull_en == 1), 0 -> use pull-down resistor
                '''
                swaccess: "rw"
                hwaccess: "hro"
                resval: "0"
            },
            {
                bits: "7"
                name: ret_en
                desc: '''
                     Enable retention mode, active-high
                '''
                swaccess: "rw"
                hwaccess: "hro"
                resval: "0"
            },
            {
                bits: "8"
                name: st_en
                desc: '''
                     Schmitt-trigger enable, active high
                '''
                swaccess: "rw"
                hwaccess: "hro"
                resval: "0"
            },
            {
                bits: "9"
                name: tx_en
                desc: '''
                     TX driver enable, active low
                '''
                swaccess: "rw"
                hwaccess: "hro"
                resval: "0"
            },
          ]
      }

       {
          name: PAD_GPIO16_MUX_SEL
          desc: '''
              Pad signal port multiplex selection for pad pad_gpio16. The programmed value defines which port
              is connected to the pad.
          '''
          swaccess: "rw"
          hwaccess: "hro"
          resval: 0
          fields: [
              {
                  bits: "4:0"
                  enum: [
                      { value: "0", name: "register", desc: "Connects the Pad to the internal configuration register."}
                      { value: "1", name: "port_gpio_gpio16", desc: "Connect port gpio16 from port group gpio to this pad." }
                      { value: "2", name: "port_i2c0_scl", desc: "Connect port scl from port group i2c0 to this pad." }
                      { value: "3", name: "port_i2c0_sda", desc: "Connect port sda from port group i2c0 to this pad." }
                      { value: "4", name: "port_i3c0_puc", desc: "Connect port puc from port group i3c0 to this pad." }
                      { value: "5", name: "port_i3c0_scl", desc: "Connect port scl from port group i3c0 to this pad." }
                      { value: "6", name: "port_i3c0_sda", desc: "Connect port sda from port group i3c0 to this pad." }
                      { value: "7", name: "port_i3c1_puc", desc: "Connect port puc from port group i3c1 to this pad." }
                      { value: "8", name: "port_i3c1_scl", desc: "Connect port scl from port group i3c1 to this pad." }
                      { value: "9", name: "port_i3c1_sda", desc: "Connect port sda from port group i3c1 to this pad." }
                      { value: "10", name: "port_qspim0_csn0", desc: "Connect port csn0 from port group qspim0 to this pad." }
                      { value: "11", name: "port_qspim0_csn1", desc: "Connect port csn1 from port group qspim0 to this pad." }
                      { value: "12", name: "port_qspim0_csn2", desc: "Connect port csn2 from port group qspim0 to this pad." }
                      { value: "13", name: "port_qspim0_csn3", desc: "Connect port csn3 from port group qspim0 to this pad." }
                      { value: "14", name: "port_qspim0_sck", desc: "Connect port sck from port group qspim0 to this pad." }
                      { value: "15", name: "port_qspim0_sdio0", desc: "Connect port sdio0 from port group qspim0 to this pad." }
                      { value: "16", name: "port_qspim0_sdio1", desc: "Connect port sdio1 from port group qspim0 to this pad." }
                      { value: "17", name: "port_qspim0_sdio2", desc: "Connect port sdio2 from port group qspim0 to this pad." }
                      { value: "18", name: "port_qspim0_sdio3", desc: "Connect port sdio3 from port group qspim0 to this pad." }
                      { value: "19", name: "port_qspis0_csn", desc: "Connect port csn from port group qspis0 to this pad." }
                      { value: "20", name: "port_qspis0_sck", desc: "Connect port sck from port group qspis0 to this pad." }
                      { value: "21", name: "port_qspis0_sdio0", desc: "Connect port sdio0 from port group qspis0 to this pad." }
                      { value: "22", name: "port_qspis0_sdio1", desc: "Connect port sdio1 from port group qspis0 to this pad." }
                      { value: "23", name: "port_qspis0_sdio2", desc: "Connect port sdio2 from port group qspis0 to this pad." }
                      { value: "24", name: "port_qspis0_sdio3", desc: "Connect port sdio3 from port group qspis0 to this pad." }
                      { value: "25", name: "port_uart0_rx", desc: "Connect port rx from port group uart0 to this pad." }
                      { value: "26", name: "port_uart0_tx", desc: "Connect port tx from port group uart0 to this pad." }
                  ]
              }
          ]
      }

      {
          name: PAD_GPIO17_CFG
          desc: '''
            Pad signal configuration.
          '''
          swaccess: "rw"
          fields: [
            {
                bits: "0"
                name: chip2pad
                desc: '''
                     Connects to pad's TX driver
                '''
                swaccess: "rw"
                hwaccess: "hro"
                resval: "0"
            },
            {
                bits: "1"
                name: drv0
                desc: '''
                     Choose the driving strength of the pad. LSB = ~3mA
                '''
                swaccess: "rw"
                hwaccess: "hro"
                resval: "0"
            },
            {
                bits: "2"
                name: drv1
                desc: '''
                     Choose the driving strength of the pad. LSB = ~3mA
                '''
                swaccess: "rw"
                hwaccess: "hro"
                resval: "0"
            },
            {
                bits: "3"
                name: drv2
                desc: '''
                     Choose the driving strength of the pad. LSB = ~3mA
                '''
                swaccess: "rw"
                hwaccess: "hro"
                resval: "0"
            },
            {
                bits: "4"
                name: drv3
                desc: '''
                     Choose the driving strength of the pad. LSB = ~3mA
                '''
                swaccess: "rw"
                hwaccess: "hro"
                resval: "1"
            },
            {
                bits: "5"
                name: pull_en
                desc: '''
                     Enable pull up/down (depends on pull_sel) resistor, active-high
                '''
                swaccess: "rw"
                hwaccess: "hro"
                resval: "0"
            },
            {
                bits: "6"
                name: pull_sel
                desc: '''
                     1 -> use pull-up resistor (if pull_en == 1), 0 -> use pull-down resistor
                '''
                swaccess: "rw"
                hwaccess: "hro"
                resval: "0"
            },
            {
                bits: "7"
                name: ret_en
                desc: '''
                     Enable retention mode, active-high
                '''
                swaccess: "rw"
                hwaccess: "hro"
                resval: "0"
            },
            {
                bits: "8"
                name: st_en
                desc: '''
                     Schmitt-trigger enable, active high
                '''
                swaccess: "rw"
                hwaccess: "hro"
                resval: "0"
            },
            {
                bits: "9"
                name: tx_en
                desc: '''
                     TX driver enable, active low
                '''
                swaccess: "rw"
                hwaccess: "hro"
                resval: "0"
            },
          ]
      }

       {
          name: PAD_GPIO17_MUX_SEL
          desc: '''
              Pad signal port multiplex selection for pad pad_gpio17. The programmed value defines which port
              is connected to the pad.
          '''
          swaccess: "rw"
          hwaccess: "hro"
          resval: 0
          fields: [
              {
                  bits: "4:0"
                  enum: [
                      { value: "0", name: "register", desc: "Connects the Pad to the internal configuration register."}
                      { value: "1", name: "port_gpio_gpio17", desc: "Connect port gpio17 from port group gpio to this pad." }
                      { value: "2", name: "port_i2c0_scl", desc: "Connect port scl from port group i2c0 to this pad." }
                      { value: "3", name: "port_i2c0_sda", desc: "Connect port sda from port group i2c0 to this pad." }
                      { value: "4", name: "port_i3c0_puc", desc: "Connect port puc from port group i3c0 to this pad." }
                      { value: "5", name: "port_i3c0_scl", desc: "Connect port scl from port group i3c0 to this pad." }
                      { value: "6", name: "port_i3c0_sda", desc: "Connect port sda from port group i3c0 to this pad." }
                      { value: "7", name: "port_i3c1_puc", desc: "Connect port puc from port group i3c1 to this pad." }
                      { value: "8", name: "port_i3c1_scl", desc: "Connect port scl from port group i3c1 to this pad." }
                      { value: "9", name: "port_i3c1_sda", desc: "Connect port sda from port group i3c1 to this pad." }
                      { value: "10", name: "port_qspim0_csn0", desc: "Connect port csn0 from port group qspim0 to this pad." }
                      { value: "11", name: "port_qspim0_csn1", desc: "Connect port csn1 from port group qspim0 to this pad." }
                      { value: "12", name: "port_qspim0_csn2", desc: "Connect port csn2 from port group qspim0 to this pad." }
                      { value: "13", name: "port_qspim0_csn3", desc: "Connect port csn3 from port group qspim0 to this pad." }
                      { value: "14", name: "port_qspim0_sck", desc: "Connect port sck from port group qspim0 to this pad." }
                      { value: "15", name: "port_qspim0_sdio0", desc: "Connect port sdio0 from port group qspim0 to this pad." }
                      { value: "16", name: "port_qspim0_sdio1", desc: "Connect port sdio1 from port group qspim0 to this pad." }
                      { value: "17", name: "port_qspim0_sdio2", desc: "Connect port sdio2 from port group qspim0 to this pad." }
                      { value: "18", name: "port_qspim0_sdio3", desc: "Connect port sdio3 from port group qspim0 to this pad." }
                      { value: "19", name: "port_qspis0_csn", desc: "Connect port csn from port group qspis0 to this pad." }
                      { value: "20", name: "port_qspis0_sck", desc: "Connect port sck from port group qspis0 to this pad." }
                      { value: "21", name: "port_qspis0_sdio0", desc: "Connect port sdio0 from port group qspis0 to this pad." }
                      { value: "22", name: "port_qspis0_sdio1", desc: "Connect port sdio1 from port group qspis0 to this pad." }
                      { value: "23", name: "port_qspis0_sdio2", desc: "Connect port sdio2 from port group qspis0 to this pad." }
                      { value: "24", name: "port_qspis0_sdio3", desc: "Connect port sdio3 from port group qspis0 to this pad." }
                      { value: "25", name: "port_uart0_rx", desc: "Connect port rx from port group uart0 to this pad." }
                      { value: "26", name: "port_uart0_tx", desc: "Connect port tx from port group uart0 to this pad." }
                  ]
              }
          ]
      }

      {
          name: PAD_GPIO18_CFG
          desc: '''
            Pad signal configuration.
          '''
          swaccess: "rw"
          fields: [
            {
                bits: "0"
                name: chip2pad
                desc: '''
                     Connects to pad's TX driver
                '''
                swaccess: "rw"
                hwaccess: "hro"
                resval: "0"
            },
            {
                bits: "1"
                name: drv0
                desc: '''
                     Choose the driving strength of the pad. LSB = ~3mA
                '''
                swaccess: "rw"
                hwaccess: "hro"
                resval: "0"
            },
            {
                bits: "2"
                name: drv1
                desc: '''
                     Choose the driving strength of the pad. LSB = ~3mA
                '''
                swaccess: "rw"
                hwaccess: "hro"
                resval: "0"
            },
            {
                bits: "3"
                name: drv2
                desc: '''
                     Choose the driving strength of the pad. LSB = ~3mA
                '''
                swaccess: "rw"
                hwaccess: "hro"
                resval: "0"
            },
            {
                bits: "4"
                name: drv3
                desc: '''
                     Choose the driving strength of the pad. LSB = ~3mA
                '''
                swaccess: "rw"
                hwaccess: "hro"
                resval: "1"
            },
            {
                bits: "5"
                name: pull_en
                desc: '''
                     Enable pull up/down (depends on pull_sel) resistor, active-high
                '''
                swaccess: "rw"
                hwaccess: "hro"
                resval: "0"
            },
            {
                bits: "6"
                name: pull_sel
                desc: '''
                     1 -> use pull-up resistor (if pull_en == 1), 0 -> use pull-down resistor
                '''
                swaccess: "rw"
                hwaccess: "hro"
                resval: "0"
            },
            {
                bits: "7"
                name: ret_en
                desc: '''
                     Enable retention mode, active-high
                '''
                swaccess: "rw"
                hwaccess: "hro"
                resval: "0"
            },
            {
                bits: "8"
                name: st_en
                desc: '''
                     Schmitt-trigger enable, active high
                '''
                swaccess: "rw"
                hwaccess: "hro"
                resval: "0"
            },
            {
                bits: "9"
                name: tx_en
                desc: '''
                     TX driver enable, active low
                '''
                swaccess: "rw"
                hwaccess: "hro"
                resval: "0"
            },
          ]
      }

       {
          name: PAD_GPIO18_MUX_SEL
          desc: '''
              Pad signal port multiplex selection for pad pad_gpio18. The programmed value defines which port
              is connected to the pad.
          '''
          swaccess: "rw"
          hwaccess: "hro"
          resval: 0
          fields: [
              {
                  bits: "4:0"
                  enum: [
                      { value: "0", name: "register", desc: "Connects the Pad to the internal configuration register."}
                      { value: "1", name: "port_gpio_gpio18", desc: "Connect port gpio18 from port group gpio to this pad." }
                      { value: "2", name: "port_i2c0_scl", desc: "Connect port scl from port group i2c0 to this pad." }
                      { value: "3", name: "port_i2c0_sda", desc: "Connect port sda from port group i2c0 to this pad." }
                      { value: "4", name: "port_i3c0_puc", desc: "Connect port puc from port group i3c0 to this pad." }
                      { value: "5", name: "port_i3c0_scl", desc: "Connect port scl from port group i3c0 to this pad." }
                      { value: "6", name: "port_i3c0_sda", desc: "Connect port sda from port group i3c0 to this pad." }
                      { value: "7", name: "port_i3c1_puc", desc: "Connect port puc from port group i3c1 to this pad." }
                      { value: "8", name: "port_i3c1_scl", desc: "Connect port scl from port group i3c1 to this pad." }
                      { value: "9", name: "port_i3c1_sda", desc: "Connect port sda from port group i3c1 to this pad." }
                      { value: "10", name: "port_qspim0_csn0", desc: "Connect port csn0 from port group qspim0 to this pad." }
                      { value: "11", name: "port_qspim0_csn1", desc: "Connect port csn1 from port group qspim0 to this pad." }
                      { value: "12", name: "port_qspim0_csn2", desc: "Connect port csn2 from port group qspim0 to this pad." }
                      { value: "13", name: "port_qspim0_csn3", desc: "Connect port csn3 from port group qspim0 to this pad." }
                      { value: "14", name: "port_qspim0_sck", desc: "Connect port sck from port group qspim0 to this pad." }
                      { value: "15", name: "port_qspim0_sdio0", desc: "Connect port sdio0 from port group qspim0 to this pad." }
                      { value: "16", name: "port_qspim0_sdio1", desc: "Connect port sdio1 from port group qspim0 to this pad." }
                      { value: "17", name: "port_qspim0_sdio2", desc: "Connect port sdio2 from port group qspim0 to this pad." }
                      { value: "18", name: "port_qspim0_sdio3", desc: "Connect port sdio3 from port group qspim0 to this pad." }
                      { value: "19", name: "port_qspis0_csn", desc: "Connect port csn from port group qspis0 to this pad." }
                      { value: "20", name: "port_qspis0_sck", desc: "Connect port sck from port group qspis0 to this pad." }
                      { value: "21", name: "port_qspis0_sdio0", desc: "Connect port sdio0 from port group qspis0 to this pad." }
                      { value: "22", name: "port_qspis0_sdio1", desc: "Connect port sdio1 from port group qspis0 to this pad." }
                      { value: "23", name: "port_qspis0_sdio2", desc: "Connect port sdio2 from port group qspis0 to this pad." }
                      { value: "24", name: "port_qspis0_sdio3", desc: "Connect port sdio3 from port group qspis0 to this pad." }
                      { value: "25", name: "port_uart0_rx", desc: "Connect port rx from port group uart0 to this pad." }
                      { value: "26", name: "port_uart0_tx", desc: "Connect port tx from port group uart0 to this pad." }
                  ]
              }
          ]
      }

      {
          name: PAD_GPIO19_CFG
          desc: '''
            Pad signal configuration.
          '''
          swaccess: "rw"
          fields: [
            {
                bits: "0"
                name: chip2pad
                desc: '''
                     Connects to pad's TX driver
                '''
                swaccess: "rw"
                hwaccess: "hro"
                resval: "0"
            },
            {
                bits: "1"
                name: drv0
                desc: '''
                     Choose the driving strength of the pad. LSB = ~3mA
                '''
                swaccess: "rw"
                hwaccess: "hro"
                resval: "0"
            },
            {
                bits: "2"
                name: drv1
                desc: '''
                     Choose the driving strength of the pad. LSB = ~3mA
                '''
                swaccess: "rw"
                hwaccess: "hro"
                resval: "0"
            },
            {
                bits: "3"
                name: drv2
                desc: '''
                     Choose the driving strength of the pad. LSB = ~3mA
                '''
                swaccess: "rw"
                hwaccess: "hro"
                resval: "0"
            },
            {
                bits: "4"
                name: drv3
                desc: '''
                     Choose the driving strength of the pad. LSB = ~3mA
                '''
                swaccess: "rw"
                hwaccess: "hro"
                resval: "1"
            },
            {
                bits: "5"
                name: pull_en
                desc: '''
                     Enable pull up/down (depends on pull_sel) resistor, active-high
                '''
                swaccess: "rw"
                hwaccess: "hro"
                resval: "0"
            },
            {
                bits: "6"
                name: pull_sel
                desc: '''
                     1 -> use pull-up resistor (if pull_en == 1), 0 -> use pull-down resistor
                '''
                swaccess: "rw"
                hwaccess: "hro"
                resval: "0"
            },
            {
                bits: "7"
                name: ret_en
                desc: '''
                     Enable retention mode, active-high
                '''
                swaccess: "rw"
                hwaccess: "hro"
                resval: "0"
            },
            {
                bits: "8"
                name: st_en
                desc: '''
                     Schmitt-trigger enable, active high
                '''
                swaccess: "rw"
                hwaccess: "hro"
                resval: "0"
            },
            {
                bits: "9"
                name: tx_en
                desc: '''
                     TX driver enable, active low
                '''
                swaccess: "rw"
                hwaccess: "hro"
                resval: "0"
            },
          ]
      }

       {
          name: PAD_GPIO19_MUX_SEL
          desc: '''
              Pad signal port multiplex selection for pad pad_gpio19. The programmed value defines which port
              is connected to the pad.
          '''
          swaccess: "rw"
          hwaccess: "hro"
          resval: 0
          fields: [
              {
                  bits: "4:0"
                  enum: [
                      { value: "0", name: "register", desc: "Connects the Pad to the internal configuration register."}
                      { value: "1", name: "port_gpio_gpio19", desc: "Connect port gpio19 from port group gpio to this pad." }
                      { value: "2", name: "port_i2c0_scl", desc: "Connect port scl from port group i2c0 to this pad." }
                      { value: "3", name: "port_i2c0_sda", desc: "Connect port sda from port group i2c0 to this pad." }
                      { value: "4", name: "port_i3c0_puc", desc: "Connect port puc from port group i3c0 to this pad." }
                      { value: "5", name: "port_i3c0_scl", desc: "Connect port scl from port group i3c0 to this pad." }
                      { value: "6", name: "port_i3c0_sda", desc: "Connect port sda from port group i3c0 to this pad." }
                      { value: "7", name: "port_i3c1_puc", desc: "Connect port puc from port group i3c1 to this pad." }
                      { value: "8", name: "port_i3c1_scl", desc: "Connect port scl from port group i3c1 to this pad." }
                      { value: "9", name: "port_i3c1_sda", desc: "Connect port sda from port group i3c1 to this pad." }
                      { value: "10", name: "port_qspim0_csn0", desc: "Connect port csn0 from port group qspim0 to this pad." }
                      { value: "11", name: "port_qspim0_csn1", desc: "Connect port csn1 from port group qspim0 to this pad." }
                      { value: "12", name: "port_qspim0_csn2", desc: "Connect port csn2 from port group qspim0 to this pad." }
                      { value: "13", name: "port_qspim0_csn3", desc: "Connect port csn3 from port group qspim0 to this pad." }
                      { value: "14", name: "port_qspim0_sck", desc: "Connect port sck from port group qspim0 to this pad." }
                      { value: "15", name: "port_qspim0_sdio0", desc: "Connect port sdio0 from port group qspim0 to this pad." }
                      { value: "16", name: "port_qspim0_sdio1", desc: "Connect port sdio1 from port group qspim0 to this pad." }
                      { value: "17", name: "port_qspim0_sdio2", desc: "Connect port sdio2 from port group qspim0 to this pad." }
                      { value: "18", name: "port_qspim0_sdio3", desc: "Connect port sdio3 from port group qspim0 to this pad." }
                      { value: "19", name: "port_qspis0_csn", desc: "Connect port csn from port group qspis0 to this pad." }
                      { value: "20", name: "port_qspis0_sck", desc: "Connect port sck from port group qspis0 to this pad." }
                      { value: "21", name: "port_qspis0_sdio0", desc: "Connect port sdio0 from port group qspis0 to this pad." }
                      { value: "22", name: "port_qspis0_sdio1", desc: "Connect port sdio1 from port group qspis0 to this pad." }
                      { value: "23", name: "port_qspis0_sdio2", desc: "Connect port sdio2 from port group qspis0 to this pad." }
                      { value: "24", name: "port_qspis0_sdio3", desc: "Connect port sdio3 from port group qspis0 to this pad." }
                      { value: "25", name: "port_uart0_rx", desc: "Connect port rx from port group uart0 to this pad." }
                      { value: "26", name: "port_uart0_tx", desc: "Connect port tx from port group uart0 to this pad." }
                  ]
              }
          ]
      }

      {
          name: PAD_GPIO20_CFG
          desc: '''
            Pad signal configuration.
          '''
          swaccess: "rw"
          fields: [
            {
                bits: "0"
                name: chip2pad
                desc: '''
                     Connects to pad's TX driver
                '''
                swaccess: "rw"
                hwaccess: "hro"
                resval: "0"
            },
            {
                bits: "1"
                name: drv0
                desc: '''
                     Choose the driving strength of the pad. LSB = ~3mA
                '''
                swaccess: "rw"
                hwaccess: "hro"
                resval: "0"
            },
            {
                bits: "2"
                name: drv1
                desc: '''
                     Choose the driving strength of the pad. LSB = ~3mA
                '''
                swaccess: "rw"
                hwaccess: "hro"
                resval: "0"
            },
            {
                bits: "3"
                name: drv2
                desc: '''
                     Choose the driving strength of the pad. LSB = ~3mA
                '''
                swaccess: "rw"
                hwaccess: "hro"
                resval: "0"
            },
            {
                bits: "4"
                name: drv3
                desc: '''
                     Choose the driving strength of the pad. LSB = ~3mA
                '''
                swaccess: "rw"
                hwaccess: "hro"
                resval: "1"
            },
            {
                bits: "5"
                name: pull_en
                desc: '''
                     Enable pull up/down (depends on pull_sel) resistor, active-high
                '''
                swaccess: "rw"
                hwaccess: "hro"
                resval: "0"
            },
            {
                bits: "6"
                name: pull_sel
                desc: '''
                     1 -> use pull-up resistor (if pull_en == 1), 0 -> use pull-down resistor
                '''
                swaccess: "rw"
                hwaccess: "hro"
                resval: "0"
            },
            {
                bits: "7"
                name: ret_en
                desc: '''
                     Enable retention mode, active-high
                '''
                swaccess: "rw"
                hwaccess: "hro"
                resval: "0"
            },
            {
                bits: "8"
                name: st_en
                desc: '''
                     Schmitt-trigger enable, active high
                '''
                swaccess: "rw"
                hwaccess: "hro"
                resval: "0"
            },
            {
                bits: "9"
                name: tx_en
                desc: '''
                     TX driver enable, active low
                '''
                swaccess: "rw"
                hwaccess: "hro"
                resval: "0"
            },
          ]
      }

       {
          name: PAD_GPIO20_MUX_SEL
          desc: '''
              Pad signal port multiplex selection for pad pad_gpio20. The programmed value defines which port
              is connected to the pad.
          '''
          swaccess: "rw"
          hwaccess: "hro"
          resval: 0
          fields: [
              {
                  bits: "4:0"
                  enum: [
                      { value: "0", name: "register", desc: "Connects the Pad to the internal configuration register."}
                      { value: "1", name: "port_gpio_gpio20", desc: "Connect port gpio20 from port group gpio to this pad." }
                      { value: "2", name: "port_i2c0_scl", desc: "Connect port scl from port group i2c0 to this pad." }
                      { value: "3", name: "port_i2c0_sda", desc: "Connect port sda from port group i2c0 to this pad." }
                      { value: "4", name: "port_i3c0_puc", desc: "Connect port puc from port group i3c0 to this pad." }
                      { value: "5", name: "port_i3c0_scl", desc: "Connect port scl from port group i3c0 to this pad." }
                      { value: "6", name: "port_i3c0_sda", desc: "Connect port sda from port group i3c0 to this pad." }
                      { value: "7", name: "port_i3c1_puc", desc: "Connect port puc from port group i3c1 to this pad." }
                      { value: "8", name: "port_i3c1_scl", desc: "Connect port scl from port group i3c1 to this pad." }
                      { value: "9", name: "port_i3c1_sda", desc: "Connect port sda from port group i3c1 to this pad." }
                      { value: "10", name: "port_qspim0_csn0", desc: "Connect port csn0 from port group qspim0 to this pad." }
                      { value: "11", name: "port_qspim0_csn1", desc: "Connect port csn1 from port group qspim0 to this pad." }
                      { value: "12", name: "port_qspim0_csn2", desc: "Connect port csn2 from port group qspim0 to this pad." }
                      { value: "13", name: "port_qspim0_csn3", desc: "Connect port csn3 from port group qspim0 to this pad." }
                      { value: "14", name: "port_qspim0_sck", desc: "Connect port sck from port group qspim0 to this pad." }
                      { value: "15", name: "port_qspim0_sdio0", desc: "Connect port sdio0 from port group qspim0 to this pad." }
                      { value: "16", name: "port_qspim0_sdio1", desc: "Connect port sdio1 from port group qspim0 to this pad." }
                      { value: "17", name: "port_qspim0_sdio2", desc: "Connect port sdio2 from port group qspim0 to this pad." }
                      { value: "18", name: "port_qspim0_sdio3", desc: "Connect port sdio3 from port group qspim0 to this pad." }
                      { value: "19", name: "port_qspis0_csn", desc: "Connect port csn from port group qspis0 to this pad." }
                      { value: "20", name: "port_qspis0_sck", desc: "Connect port sck from port group qspis0 to this pad." }
                      { value: "21", name: "port_qspis0_sdio0", desc: "Connect port sdio0 from port group qspis0 to this pad." }
                      { value: "22", name: "port_qspis0_sdio1", desc: "Connect port sdio1 from port group qspis0 to this pad." }
                      { value: "23", name: "port_qspis0_sdio2", desc: "Connect port sdio2 from port group qspis0 to this pad." }
                      { value: "24", name: "port_qspis0_sdio3", desc: "Connect port sdio3 from port group qspis0 to this pad." }
                      { value: "25", name: "port_uart0_rx", desc: "Connect port rx from port group uart0 to this pad." }
                      { value: "26", name: "port_uart0_tx", desc: "Connect port tx from port group uart0 to this pad." }
                  ]
              }
          ]
      }

      {
          name: PAD_GPIO21_CFG
          desc: '''
            Pad signal configuration.
          '''
          swaccess: "rw"
          fields: [
            {
                bits: "0"
                name: chip2pad
                desc: '''
                     Connects to pad's TX driver
                '''
                swaccess: "rw"
                hwaccess: "hro"
                resval: "0"
            },
            {
                bits: "1"
                name: drv0
                desc: '''
                     Choose the driving strength of the pad. LSB = ~3mA
                '''
                swaccess: "rw"
                hwaccess: "hro"
                resval: "0"
            },
            {
                bits: "2"
                name: drv1
                desc: '''
                     Choose the driving strength of the pad. LSB = ~3mA
                '''
                swaccess: "rw"
                hwaccess: "hro"
                resval: "0"
            },
            {
                bits: "3"
                name: drv2
                desc: '''
                     Choose the driving strength of the pad. LSB = ~3mA
                '''
                swaccess: "rw"
                hwaccess: "hro"
                resval: "0"
            },
            {
                bits: "4"
                name: drv3
                desc: '''
                     Choose the driving strength of the pad. LSB = ~3mA
                '''
                swaccess: "rw"
                hwaccess: "hro"
                resval: "1"
            },
            {
                bits: "5"
                name: pull_en
                desc: '''
                     Enable pull up/down (depends on pull_sel) resistor, active-high
                '''
                swaccess: "rw"
                hwaccess: "hro"
                resval: "0"
            },
            {
                bits: "6"
                name: pull_sel
                desc: '''
                     1 -> use pull-up resistor (if pull_en == 1), 0 -> use pull-down resistor
                '''
                swaccess: "rw"
                hwaccess: "hro"
                resval: "0"
            },
            {
                bits: "7"
                name: ret_en
                desc: '''
                     Enable retention mode, active-high
                '''
                swaccess: "rw"
                hwaccess: "hro"
                resval: "0"
            },
            {
                bits: "8"
                name: st_en
                desc: '''
                     Schmitt-trigger enable, active high
                '''
                swaccess: "rw"
                hwaccess: "hro"
                resval: "0"
            },
            {
                bits: "9"
                name: tx_en
                desc: '''
                     TX driver enable, active low
                '''
                swaccess: "rw"
                hwaccess: "hro"
                resval: "0"
            },
          ]
      }

       {
          name: PAD_GPIO21_MUX_SEL
          desc: '''
              Pad signal port multiplex selection for pad pad_gpio21. The programmed value defines which port
              is connected to the pad.
          '''
          swaccess: "rw"
          hwaccess: "hro"
          resval: 0
          fields: [
              {
                  bits: "4:0"
                  enum: [
                      { value: "0", name: "register", desc: "Connects the Pad to the internal configuration register."}
                      { value: "1", name: "port_gpio_gpio21", desc: "Connect port gpio21 from port group gpio to this pad." }
                      { value: "2", name: "port_i2c0_scl", desc: "Connect port scl from port group i2c0 to this pad." }
                      { value: "3", name: "port_i2c0_sda", desc: "Connect port sda from port group i2c0 to this pad." }
                      { value: "4", name: "port_i3c0_puc", desc: "Connect port puc from port group i3c0 to this pad." }
                      { value: "5", name: "port_i3c0_scl", desc: "Connect port scl from port group i3c0 to this pad." }
                      { value: "6", name: "port_i3c0_sda", desc: "Connect port sda from port group i3c0 to this pad." }
                      { value: "7", name: "port_i3c1_puc", desc: "Connect port puc from port group i3c1 to this pad." }
                      { value: "8", name: "port_i3c1_scl", desc: "Connect port scl from port group i3c1 to this pad." }
                      { value: "9", name: "port_i3c1_sda", desc: "Connect port sda from port group i3c1 to this pad." }
                      { value: "10", name: "port_qspim0_csn0", desc: "Connect port csn0 from port group qspim0 to this pad." }
                      { value: "11", name: "port_qspim0_csn1", desc: "Connect port csn1 from port group qspim0 to this pad." }
                      { value: "12", name: "port_qspim0_csn2", desc: "Connect port csn2 from port group qspim0 to this pad." }
                      { value: "13", name: "port_qspim0_csn3", desc: "Connect port csn3 from port group qspim0 to this pad." }
                      { value: "14", name: "port_qspim0_sck", desc: "Connect port sck from port group qspim0 to this pad." }
                      { value: "15", name: "port_qspim0_sdio0", desc: "Connect port sdio0 from port group qspim0 to this pad." }
                      { value: "16", name: "port_qspim0_sdio1", desc: "Connect port sdio1 from port group qspim0 to this pad." }
                      { value: "17", name: "port_qspim0_sdio2", desc: "Connect port sdio2 from port group qspim0 to this pad." }
                      { value: "18", name: "port_qspim0_sdio3", desc: "Connect port sdio3 from port group qspim0 to this pad." }
                      { value: "19", name: "port_qspis0_csn", desc: "Connect port csn from port group qspis0 to this pad." }
                      { value: "20", name: "port_qspis0_sck", desc: "Connect port sck from port group qspis0 to this pad." }
                      { value: "21", name: "port_qspis0_sdio0", desc: "Connect port sdio0 from port group qspis0 to this pad." }
                      { value: "22", name: "port_qspis0_sdio1", desc: "Connect port sdio1 from port group qspis0 to this pad." }
                      { value: "23", name: "port_qspis0_sdio2", desc: "Connect port sdio2 from port group qspis0 to this pad." }
                      { value: "24", name: "port_qspis0_sdio3", desc: "Connect port sdio3 from port group qspis0 to this pad." }
                      { value: "25", name: "port_uart0_rx", desc: "Connect port rx from port group uart0 to this pad." }
                      { value: "26", name: "port_uart0_tx", desc: "Connect port tx from port group uart0 to this pad." }
                  ]
              }
          ]
      }

      {
          name: PAD_GPIO22_CFG
          desc: '''
            Pad signal configuration.
          '''
          swaccess: "rw"
          fields: [
            {
                bits: "0"
                name: chip2pad
                desc: '''
                     Connects to pad's TX driver
                '''
                swaccess: "rw"
                hwaccess: "hro"
                resval: "0"
            },
            {
                bits: "1"
                name: drv0
                desc: '''
                     Choose the driving strength of the pad. LSB = ~3mA
                '''
                swaccess: "rw"
                hwaccess: "hro"
                resval: "0"
            },
            {
                bits: "2"
                name: drv1
                desc: '''
                     Choose the driving strength of the pad. LSB = ~3mA
                '''
                swaccess: "rw"
                hwaccess: "hro"
                resval: "0"
            },
            {
                bits: "3"
                name: drv2
                desc: '''
                     Choose the driving strength of the pad. LSB = ~3mA
                '''
                swaccess: "rw"
                hwaccess: "hro"
                resval: "0"
            },
            {
                bits: "4"
                name: drv3
                desc: '''
                     Choose the driving strength of the pad. LSB = ~3mA
                '''
                swaccess: "rw"
                hwaccess: "hro"
                resval: "1"
            },
            {
                bits: "5"
                name: pull_en
                desc: '''
                     Enable pull up/down (depends on pull_sel) resistor, active-high
                '''
                swaccess: "rw"
                hwaccess: "hro"
                resval: "0"
            },
            {
                bits: "6"
                name: pull_sel
                desc: '''
                     1 -> use pull-up resistor (if pull_en == 1), 0 -> use pull-down resistor
                '''
                swaccess: "rw"
                hwaccess: "hro"
                resval: "0"
            },
            {
                bits: "7"
                name: ret_en
                desc: '''
                     Enable retention mode, active-high
                '''
                swaccess: "rw"
                hwaccess: "hro"
                resval: "0"
            },
            {
                bits: "8"
                name: st_en
                desc: '''
                     Schmitt-trigger enable, active high
                '''
                swaccess: "rw"
                hwaccess: "hro"
                resval: "0"
            },
            {
                bits: "9"
                name: tx_en
                desc: '''
                     TX driver enable, active low
                '''
                swaccess: "rw"
                hwaccess: "hro"
                resval: "0"
            },
          ]
      }

       {
          name: PAD_GPIO22_MUX_SEL
          desc: '''
              Pad signal port multiplex selection for pad pad_gpio22. The programmed value defines which port
              is connected to the pad.
          '''
          swaccess: "rw"
          hwaccess: "hro"
          resval: 0
          fields: [
              {
                  bits: "4:0"
                  enum: [
                      { value: "0", name: "register", desc: "Connects the Pad to the internal configuration register."}
                      { value: "1", name: "port_gpio_gpio22", desc: "Connect port gpio22 from port group gpio to this pad." }
                      { value: "2", name: "port_i2c0_scl", desc: "Connect port scl from port group i2c0 to this pad." }
                      { value: "3", name: "port_i2c0_sda", desc: "Connect port sda from port group i2c0 to this pad." }
                      { value: "4", name: "port_i3c0_puc", desc: "Connect port puc from port group i3c0 to this pad." }
                      { value: "5", name: "port_i3c0_scl", desc: "Connect port scl from port group i3c0 to this pad." }
                      { value: "6", name: "port_i3c0_sda", desc: "Connect port sda from port group i3c0 to this pad." }
                      { value: "7", name: "port_i3c1_puc", desc: "Connect port puc from port group i3c1 to this pad." }
                      { value: "8", name: "port_i3c1_scl", desc: "Connect port scl from port group i3c1 to this pad." }
                      { value: "9", name: "port_i3c1_sda", desc: "Connect port sda from port group i3c1 to this pad." }
                      { value: "10", name: "port_qspim0_csn0", desc: "Connect port csn0 from port group qspim0 to this pad." }
                      { value: "11", name: "port_qspim0_csn1", desc: "Connect port csn1 from port group qspim0 to this pad." }
                      { value: "12", name: "port_qspim0_csn2", desc: "Connect port csn2 from port group qspim0 to this pad." }
                      { value: "13", name: "port_qspim0_csn3", desc: "Connect port csn3 from port group qspim0 to this pad." }
                      { value: "14", name: "port_qspim0_sck", desc: "Connect port sck from port group qspim0 to this pad." }
                      { value: "15", name: "port_qspim0_sdio0", desc: "Connect port sdio0 from port group qspim0 to this pad." }
                      { value: "16", name: "port_qspim0_sdio1", desc: "Connect port sdio1 from port group qspim0 to this pad." }
                      { value: "17", name: "port_qspim0_sdio2", desc: "Connect port sdio2 from port group qspim0 to this pad." }
                      { value: "18", name: "port_qspim0_sdio3", desc: "Connect port sdio3 from port group qspim0 to this pad." }
                      { value: "19", name: "port_qspis0_csn", desc: "Connect port csn from port group qspis0 to this pad." }
                      { value: "20", name: "port_qspis0_sck", desc: "Connect port sck from port group qspis0 to this pad." }
                      { value: "21", name: "port_qspis0_sdio0", desc: "Connect port sdio0 from port group qspis0 to this pad." }
                      { value: "22", name: "port_qspis0_sdio1", desc: "Connect port sdio1 from port group qspis0 to this pad." }
                      { value: "23", name: "port_qspis0_sdio2", desc: "Connect port sdio2 from port group qspis0 to this pad." }
                      { value: "24", name: "port_qspis0_sdio3", desc: "Connect port sdio3 from port group qspis0 to this pad." }
                      { value: "25", name: "port_uart0_rx", desc: "Connect port rx from port group uart0 to this pad." }
                      { value: "26", name: "port_uart0_tx", desc: "Connect port tx from port group uart0 to this pad." }
                  ]
              }
          ]
      }

      {
          name: PAD_GPIO23_CFG
          desc: '''
            Pad signal configuration.
          '''
          swaccess: "rw"
          fields: [
            {
                bits: "0"
                name: chip2pad
                desc: '''
                     Connects to pad's TX driver
                '''
                swaccess: "rw"
                hwaccess: "hro"
                resval: "0"
            },
            {
                bits: "1"
                name: drv0
                desc: '''
                     Choose the driving strength of the pad. LSB = ~3mA
                '''
                swaccess: "rw"
                hwaccess: "hro"
                resval: "0"
            },
            {
                bits: "2"
                name: drv1
                desc: '''
                     Choose the driving strength of the pad. LSB = ~3mA
                '''
                swaccess: "rw"
                hwaccess: "hro"
                resval: "0"
            },
            {
                bits: "3"
                name: drv2
                desc: '''
                     Choose the driving strength of the pad. LSB = ~3mA
                '''
                swaccess: "rw"
                hwaccess: "hro"
                resval: "0"
            },
            {
                bits: "4"
                name: drv3
                desc: '''
                     Choose the driving strength of the pad. LSB = ~3mA
                '''
                swaccess: "rw"
                hwaccess: "hro"
                resval: "1"
            },
            {
                bits: "5"
                name: pull_en
                desc: '''
                     Enable pull up/down (depends on pull_sel) resistor, active-high
                '''
                swaccess: "rw"
                hwaccess: "hro"
                resval: "0"
            },
            {
                bits: "6"
                name: pull_sel
                desc: '''
                     1 -> use pull-up resistor (if pull_en == 1), 0 -> use pull-down resistor
                '''
                swaccess: "rw"
                hwaccess: "hro"
                resval: "0"
            },
            {
                bits: "7"
                name: ret_en
                desc: '''
                     Enable retention mode, active-high
                '''
                swaccess: "rw"
                hwaccess: "hro"
                resval: "0"
            },
            {
                bits: "8"
                name: st_en
                desc: '''
                     Schmitt-trigger enable, active high
                '''
                swaccess: "rw"
                hwaccess: "hro"
                resval: "0"
            },
            {
                bits: "9"
                name: tx_en
                desc: '''
                     TX driver enable, active low
                '''
                swaccess: "rw"
                hwaccess: "hro"
                resval: "0"
            },
          ]
      }

       {
          name: PAD_GPIO23_MUX_SEL
          desc: '''
              Pad signal port multiplex selection for pad pad_gpio23. The programmed value defines which port
              is connected to the pad.
          '''
          swaccess: "rw"
          hwaccess: "hro"
          resval: 0
          fields: [
              {
                  bits: "4:0"
                  enum: [
                      { value: "0", name: "register", desc: "Connects the Pad to the internal configuration register."}
                      { value: "1", name: "port_gpio_gpio23", desc: "Connect port gpio23 from port group gpio to this pad." }
                      { value: "2", name: "port_i2c0_scl", desc: "Connect port scl from port group i2c0 to this pad." }
                      { value: "3", name: "port_i2c0_sda", desc: "Connect port sda from port group i2c0 to this pad." }
                      { value: "4", name: "port_i3c0_puc", desc: "Connect port puc from port group i3c0 to this pad." }
                      { value: "5", name: "port_i3c0_scl", desc: "Connect port scl from port group i3c0 to this pad." }
                      { value: "6", name: "port_i3c0_sda", desc: "Connect port sda from port group i3c0 to this pad." }
                      { value: "7", name: "port_i3c1_puc", desc: "Connect port puc from port group i3c1 to this pad." }
                      { value: "8", name: "port_i3c1_scl", desc: "Connect port scl from port group i3c1 to this pad." }
                      { value: "9", name: "port_i3c1_sda", desc: "Connect port sda from port group i3c1 to this pad." }
                      { value: "10", name: "port_qspim0_csn0", desc: "Connect port csn0 from port group qspim0 to this pad." }
                      { value: "11", name: "port_qspim0_csn1", desc: "Connect port csn1 from port group qspim0 to this pad." }
                      { value: "12", name: "port_qspim0_csn2", desc: "Connect port csn2 from port group qspim0 to this pad." }
                      { value: "13", name: "port_qspim0_csn3", desc: "Connect port csn3 from port group qspim0 to this pad." }
                      { value: "14", name: "port_qspim0_sck", desc: "Connect port sck from port group qspim0 to this pad." }
                      { value: "15", name: "port_qspim0_sdio0", desc: "Connect port sdio0 from port group qspim0 to this pad." }
                      { value: "16", name: "port_qspim0_sdio1", desc: "Connect port sdio1 from port group qspim0 to this pad." }
                      { value: "17", name: "port_qspim0_sdio2", desc: "Connect port sdio2 from port group qspim0 to this pad." }
                      { value: "18", name: "port_qspim0_sdio3", desc: "Connect port sdio3 from port group qspim0 to this pad." }
                      { value: "19", name: "port_qspis0_csn", desc: "Connect port csn from port group qspis0 to this pad." }
                      { value: "20", name: "port_qspis0_sck", desc: "Connect port sck from port group qspis0 to this pad." }
                      { value: "21", name: "port_qspis0_sdio0", desc: "Connect port sdio0 from port group qspis0 to this pad." }
                      { value: "22", name: "port_qspis0_sdio1", desc: "Connect port sdio1 from port group qspis0 to this pad." }
                      { value: "23", name: "port_qspis0_sdio2", desc: "Connect port sdio2 from port group qspis0 to this pad." }
                      { value: "24", name: "port_qspis0_sdio3", desc: "Connect port sdio3 from port group qspis0 to this pad." }
                      { value: "25", name: "port_uart0_rx", desc: "Connect port rx from port group uart0 to this pad." }
                      { value: "26", name: "port_uart0_tx", desc: "Connect port tx from port group uart0 to this pad." }
                  ]
              }
          ]
      }

      {
          name: PAD_GPIO24_CFG
          desc: '''
            Pad signal configuration.
          '''
          swaccess: "rw"
          fields: [
            {
                bits: "0"
                name: chip2pad
                desc: '''
                     Connects to pad's TX driver
                '''
                swaccess: "rw"
                hwaccess: "hro"
                resval: "0"
            },
            {
                bits: "1"
                name: drv0
                desc: '''
                     Choose the driving strength of the pad. LSB = ~3mA
                '''
                swaccess: "rw"
                hwaccess: "hro"
                resval: "0"
            },
            {
                bits: "2"
                name: drv1
                desc: '''
                     Choose the driving strength of the pad. LSB = ~3mA
                '''
                swaccess: "rw"
                hwaccess: "hro"
                resval: "0"
            },
            {
                bits: "3"
                name: drv2
                desc: '''
                     Choose the driving strength of the pad. LSB = ~3mA
                '''
                swaccess: "rw"
                hwaccess: "hro"
                resval: "0"
            },
            {
                bits: "4"
                name: drv3
                desc: '''
                     Choose the driving strength of the pad. LSB = ~3mA
                '''
                swaccess: "rw"
                hwaccess: "hro"
                resval: "1"
            },
            {
                bits: "5"
                name: pull_en
                desc: '''
                     Enable pull up/down (depends on pull_sel) resistor, active-high
                '''
                swaccess: "rw"
                hwaccess: "hro"
                resval: "0"
            },
            {
                bits: "6"
                name: pull_sel
                desc: '''
                     1 -> use pull-up resistor (if pull_en == 1), 0 -> use pull-down resistor
                '''
                swaccess: "rw"
                hwaccess: "hro"
                resval: "0"
            },
            {
                bits: "7"
                name: ret_en
                desc: '''
                     Enable retention mode, active-high
                '''
                swaccess: "rw"
                hwaccess: "hro"
                resval: "0"
            },
            {
                bits: "8"
                name: st_en
                desc: '''
                     Schmitt-trigger enable, active high
                '''
                swaccess: "rw"
                hwaccess: "hro"
                resval: "0"
            },
            {
                bits: "9"
                name: tx_en
                desc: '''
                     TX driver enable, active low
                '''
                swaccess: "rw"
                hwaccess: "hro"
                resval: "0"
            },
          ]
      }

       {
          name: PAD_GPIO24_MUX_SEL
          desc: '''
              Pad signal port multiplex selection for pad pad_gpio24. The programmed value defines which port
              is connected to the pad.
          '''
          swaccess: "rw"
          hwaccess: "hro"
          resval: 0
          fields: [
              {
                  bits: "4:0"
                  enum: [
                      { value: "0", name: "register", desc: "Connects the Pad to the internal configuration register."}
                      { value: "1", name: "port_gpio_gpio24", desc: "Connect port gpio24 from port group gpio to this pad." }
                      { value: "2", name: "port_i2c0_scl", desc: "Connect port scl from port group i2c0 to this pad." }
                      { value: "3", name: "port_i2c0_sda", desc: "Connect port sda from port group i2c0 to this pad." }
                      { value: "4", name: "port_i3c0_puc", desc: "Connect port puc from port group i3c0 to this pad." }
                      { value: "5", name: "port_i3c0_scl", desc: "Connect port scl from port group i3c0 to this pad." }
                      { value: "6", name: "port_i3c0_sda", desc: "Connect port sda from port group i3c0 to this pad." }
                      { value: "7", name: "port_i3c1_puc", desc: "Connect port puc from port group i3c1 to this pad." }
                      { value: "8", name: "port_i3c1_scl", desc: "Connect port scl from port group i3c1 to this pad." }
                      { value: "9", name: "port_i3c1_sda", desc: "Connect port sda from port group i3c1 to this pad." }
                      { value: "10", name: "port_qspim0_csn0", desc: "Connect port csn0 from port group qspim0 to this pad." }
                      { value: "11", name: "port_qspim0_csn1", desc: "Connect port csn1 from port group qspim0 to this pad." }
                      { value: "12", name: "port_qspim0_csn2", desc: "Connect port csn2 from port group qspim0 to this pad." }
                      { value: "13", name: "port_qspim0_csn3", desc: "Connect port csn3 from port group qspim0 to this pad." }
                      { value: "14", name: "port_qspim0_sck", desc: "Connect port sck from port group qspim0 to this pad." }
                      { value: "15", name: "port_qspim0_sdio0", desc: "Connect port sdio0 from port group qspim0 to this pad." }
                      { value: "16", name: "port_qspim0_sdio1", desc: "Connect port sdio1 from port group qspim0 to this pad." }
                      { value: "17", name: "port_qspim0_sdio2", desc: "Connect port sdio2 from port group qspim0 to this pad." }
                      { value: "18", name: "port_qspim0_sdio3", desc: "Connect port sdio3 from port group qspim0 to this pad." }
                      { value: "19", name: "port_qspis0_csn", desc: "Connect port csn from port group qspis0 to this pad." }
                      { value: "20", name: "port_qspis0_sck", desc: "Connect port sck from port group qspis0 to this pad." }
                      { value: "21", name: "port_qspis0_sdio0", desc: "Connect port sdio0 from port group qspis0 to this pad." }
                      { value: "22", name: "port_qspis0_sdio1", desc: "Connect port sdio1 from port group qspis0 to this pad." }
                      { value: "23", name: "port_qspis0_sdio2", desc: "Connect port sdio2 from port group qspis0 to this pad." }
                      { value: "24", name: "port_qspis0_sdio3", desc: "Connect port sdio3 from port group qspis0 to this pad." }
                      { value: "25", name: "port_uart0_rx", desc: "Connect port rx from port group uart0 to this pad." }
                      { value: "26", name: "port_uart0_tx", desc: "Connect port tx from port group uart0 to this pad." }
                  ]
              }
          ]
      }

      {
          name: PAD_GPIO25_CFG
          desc: '''
            Pad signal configuration.
          '''
          swaccess: "rw"
          fields: [
            {
                bits: "0"
                name: chip2pad
                desc: '''
                     Connects to pad's TX driver
                '''
                swaccess: "rw"
                hwaccess: "hro"
                resval: "0"
            },
            {
                bits: "1"
                name: drv0
                desc: '''
                     Choose the driving strength of the pad. LSB = ~3mA
                '''
                swaccess: "rw"
                hwaccess: "hro"
                resval: "0"
            },
            {
                bits: "2"
                name: drv1
                desc: '''
                     Choose the driving strength of the pad. LSB = ~3mA
                '''
                swaccess: "rw"
                hwaccess: "hro"
                resval: "0"
            },
            {
                bits: "3"
                name: drv2
                desc: '''
                     Choose the driving strength of the pad. LSB = ~3mA
                '''
                swaccess: "rw"
                hwaccess: "hro"
                resval: "0"
            },
            {
                bits: "4"
                name: drv3
                desc: '''
                     Choose the driving strength of the pad. LSB = ~3mA
                '''
                swaccess: "rw"
                hwaccess: "hro"
                resval: "1"
            },
            {
                bits: "5"
                name: pull_en
                desc: '''
                     Enable pull up/down (depends on pull_sel) resistor, active-high
                '''
                swaccess: "rw"
                hwaccess: "hro"
                resval: "0"
            },
            {
                bits: "6"
                name: pull_sel
                desc: '''
                     1 -> use pull-up resistor (if pull_en == 1), 0 -> use pull-down resistor
                '''
                swaccess: "rw"
                hwaccess: "hro"
                resval: "0"
            },
            {
                bits: "7"
                name: ret_en
                desc: '''
                     Enable retention mode, active-high
                '''
                swaccess: "rw"
                hwaccess: "hro"
                resval: "0"
            },
            {
                bits: "8"
                name: st_en
                desc: '''
                     Schmitt-trigger enable, active high
                '''
                swaccess: "rw"
                hwaccess: "hro"
                resval: "0"
            },
            {
                bits: "9"
                name: tx_en
                desc: '''
                     TX driver enable, active low
                '''
                swaccess: "rw"
                hwaccess: "hro"
                resval: "0"
            },
          ]
      }

       {
          name: PAD_GPIO25_MUX_SEL
          desc: '''
              Pad signal port multiplex selection for pad pad_gpio25. The programmed value defines which port
              is connected to the pad.
          '''
          swaccess: "rw"
          hwaccess: "hro"
          resval: 0
          fields: [
              {
                  bits: "4:0"
                  enum: [
                      { value: "0", name: "register", desc: "Connects the Pad to the internal configuration register."}
                      { value: "1", name: "port_gpio_gpio25", desc: "Connect port gpio25 from port group gpio to this pad." }
                      { value: "2", name: "port_i2c0_scl", desc: "Connect port scl from port group i2c0 to this pad." }
                      { value: "3", name: "port_i2c0_sda", desc: "Connect port sda from port group i2c0 to this pad." }
                      { value: "4", name: "port_i3c0_puc", desc: "Connect port puc from port group i3c0 to this pad." }
                      { value: "5", name: "port_i3c0_scl", desc: "Connect port scl from port group i3c0 to this pad." }
                      { value: "6", name: "port_i3c0_sda", desc: "Connect port sda from port group i3c0 to this pad." }
                      { value: "7", name: "port_i3c1_puc", desc: "Connect port puc from port group i3c1 to this pad." }
                      { value: "8", name: "port_i3c1_scl", desc: "Connect port scl from port group i3c1 to this pad." }
                      { value: "9", name: "port_i3c1_sda", desc: "Connect port sda from port group i3c1 to this pad." }
                      { value: "10", name: "port_qspim0_csn0", desc: "Connect port csn0 from port group qspim0 to this pad." }
                      { value: "11", name: "port_qspim0_csn1", desc: "Connect port csn1 from port group qspim0 to this pad." }
                      { value: "12", name: "port_qspim0_csn2", desc: "Connect port csn2 from port group qspim0 to this pad." }
                      { value: "13", name: "port_qspim0_csn3", desc: "Connect port csn3 from port group qspim0 to this pad." }
                      { value: "14", name: "port_qspim0_sck", desc: "Connect port sck from port group qspim0 to this pad." }
                      { value: "15", name: "port_qspim0_sdio0", desc: "Connect port sdio0 from port group qspim0 to this pad." }
                      { value: "16", name: "port_qspim0_sdio1", desc: "Connect port sdio1 from port group qspim0 to this pad." }
                      { value: "17", name: "port_qspim0_sdio2", desc: "Connect port sdio2 from port group qspim0 to this pad." }
                      { value: "18", name: "port_qspim0_sdio3", desc: "Connect port sdio3 from port group qspim0 to this pad." }
                      { value: "19", name: "port_qspis0_csn", desc: "Connect port csn from port group qspis0 to this pad." }
                      { value: "20", name: "port_qspis0_sck", desc: "Connect port sck from port group qspis0 to this pad." }
                      { value: "21", name: "port_qspis0_sdio0", desc: "Connect port sdio0 from port group qspis0 to this pad." }
                      { value: "22", name: "port_qspis0_sdio1", desc: "Connect port sdio1 from port group qspis0 to this pad." }
                      { value: "23", name: "port_qspis0_sdio2", desc: "Connect port sdio2 from port group qspis0 to this pad." }
                      { value: "24", name: "port_qspis0_sdio3", desc: "Connect port sdio3 from port group qspis0 to this pad." }
                      { value: "25", name: "port_uart0_rx", desc: "Connect port rx from port group uart0 to this pad." }
                      { value: "26", name: "port_uart0_tx", desc: "Connect port tx from port group uart0 to this pad." }
                  ]
              }
          ]
      }

      {
          name: PAD_GPIO26_CFG
          desc: '''
            Pad signal configuration.
          '''
          swaccess: "rw"
          fields: [
            {
                bits: "0"
                name: chip2pad
                desc: '''
                     Connects to pad's TX driver
                '''
                swaccess: "rw"
                hwaccess: "hro"
                resval: "0"
            },
            {
                bits: "1"
                name: drv0
                desc: '''
                     Choose the driving strength of the pad. LSB = ~3mA
                '''
                swaccess: "rw"
                hwaccess: "hro"
                resval: "0"
            },
            {
                bits: "2"
                name: drv1
                desc: '''
                     Choose the driving strength of the pad. LSB = ~3mA
                '''
                swaccess: "rw"
                hwaccess: "hro"
                resval: "0"
            },
            {
                bits: "3"
                name: drv2
                desc: '''
                     Choose the driving strength of the pad. LSB = ~3mA
                '''
                swaccess: "rw"
                hwaccess: "hro"
                resval: "0"
            },
            {
                bits: "4"
                name: drv3
                desc: '''
                     Choose the driving strength of the pad. LSB = ~3mA
                '''
                swaccess: "rw"
                hwaccess: "hro"
                resval: "1"
            },
            {
                bits: "5"
                name: pull_en
                desc: '''
                     Enable pull up/down (depends on pull_sel) resistor, active-high
                '''
                swaccess: "rw"
                hwaccess: "hro"
                resval: "0"
            },
            {
                bits: "6"
                name: pull_sel
                desc: '''
                     1 -> use pull-up resistor (if pull_en == 1), 0 -> use pull-down resistor
                '''
                swaccess: "rw"
                hwaccess: "hro"
                resval: "0"
            },
            {
                bits: "7"
                name: ret_en
                desc: '''
                     Enable retention mode, active-high
                '''
                swaccess: "rw"
                hwaccess: "hro"
                resval: "0"
            },
            {
                bits: "8"
                name: st_en
                desc: '''
                     Schmitt-trigger enable, active high
                '''
                swaccess: "rw"
                hwaccess: "hro"
                resval: "0"
            },
            {
                bits: "9"
                name: tx_en
                desc: '''
                     TX driver enable, active low
                '''
                swaccess: "rw"
                hwaccess: "hro"
                resval: "0"
            },
          ]
      }

       {
          name: PAD_GPIO26_MUX_SEL
          desc: '''
              Pad signal port multiplex selection for pad pad_gpio26. The programmed value defines which port
              is connected to the pad.
          '''
          swaccess: "rw"
          hwaccess: "hro"
          resval: 0
          fields: [
              {
                  bits: "4:0"
                  enum: [
                      { value: "0", name: "register", desc: "Connects the Pad to the internal configuration register."}
                      { value: "1", name: "port_gpio_gpio26", desc: "Connect port gpio26 from port group gpio to this pad." }
                      { value: "2", name: "port_i2c0_scl", desc: "Connect port scl from port group i2c0 to this pad." }
                      { value: "3", name: "port_i2c0_sda", desc: "Connect port sda from port group i2c0 to this pad." }
                      { value: "4", name: "port_i3c0_puc", desc: "Connect port puc from port group i3c0 to this pad." }
                      { value: "5", name: "port_i3c0_scl", desc: "Connect port scl from port group i3c0 to this pad." }
                      { value: "6", name: "port_i3c0_sda", desc: "Connect port sda from port group i3c0 to this pad." }
                      { value: "7", name: "port_i3c1_puc", desc: "Connect port puc from port group i3c1 to this pad." }
                      { value: "8", name: "port_i3c1_scl", desc: "Connect port scl from port group i3c1 to this pad." }
                      { value: "9", name: "port_i3c1_sda", desc: "Connect port sda from port group i3c1 to this pad." }
                      { value: "10", name: "port_qspim0_csn0", desc: "Connect port csn0 from port group qspim0 to this pad." }
                      { value: "11", name: "port_qspim0_csn1", desc: "Connect port csn1 from port group qspim0 to this pad." }
                      { value: "12", name: "port_qspim0_csn2", desc: "Connect port csn2 from port group qspim0 to this pad." }
                      { value: "13", name: "port_qspim0_csn3", desc: "Connect port csn3 from port group qspim0 to this pad." }
                      { value: "14", name: "port_qspim0_sck", desc: "Connect port sck from port group qspim0 to this pad." }
                      { value: "15", name: "port_qspim0_sdio0", desc: "Connect port sdio0 from port group qspim0 to this pad." }
                      { value: "16", name: "port_qspim0_sdio1", desc: "Connect port sdio1 from port group qspim0 to this pad." }
                      { value: "17", name: "port_qspim0_sdio2", desc: "Connect port sdio2 from port group qspim0 to this pad." }
                      { value: "18", name: "port_qspim0_sdio3", desc: "Connect port sdio3 from port group qspim0 to this pad." }
                      { value: "19", name: "port_qspis0_csn", desc: "Connect port csn from port group qspis0 to this pad." }
                      { value: "20", name: "port_qspis0_sck", desc: "Connect port sck from port group qspis0 to this pad." }
                      { value: "21", name: "port_qspis0_sdio0", desc: "Connect port sdio0 from port group qspis0 to this pad." }
                      { value: "22", name: "port_qspis0_sdio1", desc: "Connect port sdio1 from port group qspis0 to this pad." }
                      { value: "23", name: "port_qspis0_sdio2", desc: "Connect port sdio2 from port group qspis0 to this pad." }
                      { value: "24", name: "port_qspis0_sdio3", desc: "Connect port sdio3 from port group qspis0 to this pad." }
                      { value: "25", name: "port_uart0_rx", desc: "Connect port rx from port group uart0 to this pad." }
                      { value: "26", name: "port_uart0_tx", desc: "Connect port tx from port group uart0 to this pad." }
                  ]
              }
          ]
      }

      {
          name: PAD_GPIO27_CFG
          desc: '''
            Pad signal configuration.
          '''
          swaccess: "rw"
          fields: [
            {
                bits: "0"
                name: chip2pad
                desc: '''
                     Connects to pad's TX driver
                '''
                swaccess: "rw"
                hwaccess: "hro"
                resval: "0"
            },
            {
                bits: "1"
                name: drv0
                desc: '''
                     Choose the driving strength of the pad. LSB = ~3mA
                '''
                swaccess: "rw"
                hwaccess: "hro"
                resval: "0"
            },
            {
                bits: "2"
                name: drv1
                desc: '''
                     Choose the driving strength of the pad. LSB = ~3mA
                '''
                swaccess: "rw"
                hwaccess: "hro"
                resval: "0"
            },
            {
                bits: "3"
                name: drv2
                desc: '''
                     Choose the driving strength of the pad. LSB = ~3mA
                '''
                swaccess: "rw"
                hwaccess: "hro"
                resval: "0"
            },
            {
                bits: "4"
                name: drv3
                desc: '''
                     Choose the driving strength of the pad. LSB = ~3mA
                '''
                swaccess: "rw"
                hwaccess: "hro"
                resval: "1"
            },
            {
                bits: "5"
                name: pull_en
                desc: '''
                     Enable pull up/down (depends on pull_sel) resistor, active-high
                '''
                swaccess: "rw"
                hwaccess: "hro"
                resval: "0"
            },
            {
                bits: "6"
                name: pull_sel
                desc: '''
                     1 -> use pull-up resistor (if pull_en == 1), 0 -> use pull-down resistor
                '''
                swaccess: "rw"
                hwaccess: "hro"
                resval: "0"
            },
            {
                bits: "7"
                name: ret_en
                desc: '''
                     Enable retention mode, active-high
                '''
                swaccess: "rw"
                hwaccess: "hro"
                resval: "0"
            },
            {
                bits: "8"
                name: st_en
                desc: '''
                     Schmitt-trigger enable, active high
                '''
                swaccess: "rw"
                hwaccess: "hro"
                resval: "0"
            },
            {
                bits: "9"
                name: tx_en
                desc: '''
                     TX driver enable, active low
                '''
                swaccess: "rw"
                hwaccess: "hro"
                resval: "0"
            },
          ]
      }

       {
          name: PAD_GPIO27_MUX_SEL
          desc: '''
              Pad signal port multiplex selection for pad pad_gpio27. The programmed value defines which port
              is connected to the pad.
          '''
          swaccess: "rw"
          hwaccess: "hro"
          resval: 0
          fields: [
              {
                  bits: "4:0"
                  enum: [
                      { value: "0", name: "register", desc: "Connects the Pad to the internal configuration register."}
                      { value: "1", name: "port_gpio_gpio27", desc: "Connect port gpio27 from port group gpio to this pad." }
                      { value: "2", name: "port_i2c0_scl", desc: "Connect port scl from port group i2c0 to this pad." }
                      { value: "3", name: "port_i2c0_sda", desc: "Connect port sda from port group i2c0 to this pad." }
                      { value: "4", name: "port_i3c0_puc", desc: "Connect port puc from port group i3c0 to this pad." }
                      { value: "5", name: "port_i3c0_scl", desc: "Connect port scl from port group i3c0 to this pad." }
                      { value: "6", name: "port_i3c0_sda", desc: "Connect port sda from port group i3c0 to this pad." }
                      { value: "7", name: "port_i3c1_puc", desc: "Connect port puc from port group i3c1 to this pad." }
                      { value: "8", name: "port_i3c1_scl", desc: "Connect port scl from port group i3c1 to this pad." }
                      { value: "9", name: "port_i3c1_sda", desc: "Connect port sda from port group i3c1 to this pad." }
                      { value: "10", name: "port_qspim0_csn0", desc: "Connect port csn0 from port group qspim0 to this pad." }
                      { value: "11", name: "port_qspim0_csn1", desc: "Connect port csn1 from port group qspim0 to this pad." }
                      { value: "12", name: "port_qspim0_csn2", desc: "Connect port csn2 from port group qspim0 to this pad." }
                      { value: "13", name: "port_qspim0_csn3", desc: "Connect port csn3 from port group qspim0 to this pad." }
                      { value: "14", name: "port_qspim0_sck", desc: "Connect port sck from port group qspim0 to this pad." }
                      { value: "15", name: "port_qspim0_sdio0", desc: "Connect port sdio0 from port group qspim0 to this pad." }
                      { value: "16", name: "port_qspim0_sdio1", desc: "Connect port sdio1 from port group qspim0 to this pad." }
                      { value: "17", name: "port_qspim0_sdio2", desc: "Connect port sdio2 from port group qspim0 to this pad." }
                      { value: "18", name: "port_qspim0_sdio3", desc: "Connect port sdio3 from port group qspim0 to this pad." }
                      { value: "19", name: "port_qspis0_csn", desc: "Connect port csn from port group qspis0 to this pad." }
                      { value: "20", name: "port_qspis0_sck", desc: "Connect port sck from port group qspis0 to this pad." }
                      { value: "21", name: "port_qspis0_sdio0", desc: "Connect port sdio0 from port group qspis0 to this pad." }
                      { value: "22", name: "port_qspis0_sdio1", desc: "Connect port sdio1 from port group qspis0 to this pad." }
                      { value: "23", name: "port_qspis0_sdio2", desc: "Connect port sdio2 from port group qspis0 to this pad." }
                      { value: "24", name: "port_qspis0_sdio3", desc: "Connect port sdio3 from port group qspis0 to this pad." }
                      { value: "25", name: "port_uart0_rx", desc: "Connect port rx from port group uart0 to this pad." }
                      { value: "26", name: "port_uart0_tx", desc: "Connect port tx from port group uart0 to this pad." }
                  ]
              }
          ]
      }

      {
          name: PAD_GPIO28_CFG
          desc: '''
            Pad signal configuration.
          '''
          swaccess: "rw"
          fields: [
            {
                bits: "0"
                name: chip2pad
                desc: '''
                     Connects to pad's TX driver
                '''
                swaccess: "rw"
                hwaccess: "hro"
                resval: "0"
            },
            {
                bits: "1"
                name: drv0
                desc: '''
                     Choose the driving strength of the pad. LSB = ~3mA
                '''
                swaccess: "rw"
                hwaccess: "hro"
                resval: "0"
            },
            {
                bits: "2"
                name: drv1
                desc: '''
                     Choose the driving strength of the pad. LSB = ~3mA
                '''
                swaccess: "rw"
                hwaccess: "hro"
                resval: "0"
            },
            {
                bits: "3"
                name: drv2
                desc: '''
                     Choose the driving strength of the pad. LSB = ~3mA
                '''
                swaccess: "rw"
                hwaccess: "hro"
                resval: "0"
            },
            {
                bits: "4"
                name: drv3
                desc: '''
                     Choose the driving strength of the pad. LSB = ~3mA
                '''
                swaccess: "rw"
                hwaccess: "hro"
                resval: "1"
            },
            {
                bits: "5"
                name: pull_en
                desc: '''
                     Enable pull up/down (depends on pull_sel) resistor, active-high
                '''
                swaccess: "rw"
                hwaccess: "hro"
                resval: "0"
            },
            {
                bits: "6"
                name: pull_sel
                desc: '''
                     1 -> use pull-up resistor (if pull_en == 1), 0 -> use pull-down resistor
                '''
                swaccess: "rw"
                hwaccess: "hro"
                resval: "0"
            },
            {
                bits: "7"
                name: ret_en
                desc: '''
                     Enable retention mode, active-high
                '''
                swaccess: "rw"
                hwaccess: "hro"
                resval: "0"
            },
            {
                bits: "8"
                name: st_en
                desc: '''
                     Schmitt-trigger enable, active high
                '''
                swaccess: "rw"
                hwaccess: "hro"
                resval: "0"
            },
            {
                bits: "9"
                name: tx_en
                desc: '''
                     TX driver enable, active low
                '''
                swaccess: "rw"
                hwaccess: "hro"
                resval: "0"
            },
          ]
      }

       {
          name: PAD_GPIO28_MUX_SEL
          desc: '''
              Pad signal port multiplex selection for pad pad_gpio28. The programmed value defines which port
              is connected to the pad.
          '''
          swaccess: "rw"
          hwaccess: "hro"
          resval: 0
          fields: [
              {
                  bits: "4:0"
                  enum: [
                      { value: "0", name: "register", desc: "Connects the Pad to the internal configuration register."}
                      { value: "1", name: "port_gpio_gpio28", desc: "Connect port gpio28 from port group gpio to this pad." }
                      { value: "2", name: "port_i2c0_scl", desc: "Connect port scl from port group i2c0 to this pad." }
                      { value: "3", name: "port_i2c0_sda", desc: "Connect port sda from port group i2c0 to this pad." }
                      { value: "4", name: "port_i3c0_puc", desc: "Connect port puc from port group i3c0 to this pad." }
                      { value: "5", name: "port_i3c0_scl", desc: "Connect port scl from port group i3c0 to this pad." }
                      { value: "6", name: "port_i3c0_sda", desc: "Connect port sda from port group i3c0 to this pad." }
                      { value: "7", name: "port_i3c1_puc", desc: "Connect port puc from port group i3c1 to this pad." }
                      { value: "8", name: "port_i3c1_scl", desc: "Connect port scl from port group i3c1 to this pad." }
                      { value: "9", name: "port_i3c1_sda", desc: "Connect port sda from port group i3c1 to this pad." }
                      { value: "10", name: "port_qspim0_csn0", desc: "Connect port csn0 from port group qspim0 to this pad." }
                      { value: "11", name: "port_qspim0_csn1", desc: "Connect port csn1 from port group qspim0 to this pad." }
                      { value: "12", name: "port_qspim0_csn2", desc: "Connect port csn2 from port group qspim0 to this pad." }
                      { value: "13", name: "port_qspim0_csn3", desc: "Connect port csn3 from port group qspim0 to this pad." }
                      { value: "14", name: "port_qspim0_sck", desc: "Connect port sck from port group qspim0 to this pad." }
                      { value: "15", name: "port_qspim0_sdio0", desc: "Connect port sdio0 from port group qspim0 to this pad." }
                      { value: "16", name: "port_qspim0_sdio1", desc: "Connect port sdio1 from port group qspim0 to this pad." }
                      { value: "17", name: "port_qspim0_sdio2", desc: "Connect port sdio2 from port group qspim0 to this pad." }
                      { value: "18", name: "port_qspim0_sdio3", desc: "Connect port sdio3 from port group qspim0 to this pad." }
                      { value: "19", name: "port_qspis0_csn", desc: "Connect port csn from port group qspis0 to this pad." }
                      { value: "20", name: "port_qspis0_sck", desc: "Connect port sck from port group qspis0 to this pad." }
                      { value: "21", name: "port_qspis0_sdio0", desc: "Connect port sdio0 from port group qspis0 to this pad." }
                      { value: "22", name: "port_qspis0_sdio1", desc: "Connect port sdio1 from port group qspis0 to this pad." }
                      { value: "23", name: "port_qspis0_sdio2", desc: "Connect port sdio2 from port group qspis0 to this pad." }
                      { value: "24", name: "port_qspis0_sdio3", desc: "Connect port sdio3 from port group qspis0 to this pad." }
                      { value: "25", name: "port_uart0_rx", desc: "Connect port rx from port group uart0 to this pad." }
                      { value: "26", name: "port_uart0_tx", desc: "Connect port tx from port group uart0 to this pad." }
                  ]
              }
          ]
      }

      {
          name: PAD_GPIO29_CFG
          desc: '''
            Pad signal configuration.
          '''
          swaccess: "rw"
          fields: [
            {
                bits: "0"
                name: chip2pad
                desc: '''
                     Connects to pad's TX driver
                '''
                swaccess: "rw"
                hwaccess: "hro"
                resval: "0"
            },
            {
                bits: "1"
                name: drv0
                desc: '''
                     Choose the driving strength of the pad. LSB = ~3mA
                '''
                swaccess: "rw"
                hwaccess: "hro"
                resval: "0"
            },
            {
                bits: "2"
                name: drv1
                desc: '''
                     Choose the driving strength of the pad. LSB = ~3mA
                '''
                swaccess: "rw"
                hwaccess: "hro"
                resval: "0"
            },
            {
                bits: "3"
                name: drv2
                desc: '''
                     Choose the driving strength of the pad. LSB = ~3mA
                '''
                swaccess: "rw"
                hwaccess: "hro"
                resval: "0"
            },
            {
                bits: "4"
                name: drv3
                desc: '''
                     Choose the driving strength of the pad. LSB = ~3mA
                '''
                swaccess: "rw"
                hwaccess: "hro"
                resval: "1"
            },
            {
                bits: "5"
                name: pull_en
                desc: '''
                     Enable pull up/down (depends on pull_sel) resistor, active-high
                '''
                swaccess: "rw"
                hwaccess: "hro"
                resval: "0"
            },
            {
                bits: "6"
                name: pull_sel
                desc: '''
                     1 -> use pull-up resistor (if pull_en == 1), 0 -> use pull-down resistor
                '''
                swaccess: "rw"
                hwaccess: "hro"
                resval: "0"
            },
            {
                bits: "7"
                name: ret_en
                desc: '''
                     Enable retention mode, active-high
                '''
                swaccess: "rw"
                hwaccess: "hro"
                resval: "0"
            },
            {
                bits: "8"
                name: st_en
                desc: '''
                     Schmitt-trigger enable, active high
                '''
                swaccess: "rw"
                hwaccess: "hro"
                resval: "0"
            },
            {
                bits: "9"
                name: tx_en
                desc: '''
                     TX driver enable, active low
                '''
                swaccess: "rw"
                hwaccess: "hro"
                resval: "0"
            },
          ]
      }

       {
          name: PAD_GPIO29_MUX_SEL
          desc: '''
              Pad signal port multiplex selection for pad pad_gpio29. The programmed value defines which port
              is connected to the pad.
          '''
          swaccess: "rw"
          hwaccess: "hro"
          resval: 0
          fields: [
              {
                  bits: "4:0"
                  enum: [
                      { value: "0", name: "register", desc: "Connects the Pad to the internal configuration register."}
                      { value: "1", name: "port_gpio_gpio29", desc: "Connect port gpio29 from port group gpio to this pad." }
                      { value: "2", name: "port_i2c0_scl", desc: "Connect port scl from port group i2c0 to this pad." }
                      { value: "3", name: "port_i2c0_sda", desc: "Connect port sda from port group i2c0 to this pad." }
                      { value: "4", name: "port_i3c0_puc", desc: "Connect port puc from port group i3c0 to this pad." }
                      { value: "5", name: "port_i3c0_scl", desc: "Connect port scl from port group i3c0 to this pad." }
                      { value: "6", name: "port_i3c0_sda", desc: "Connect port sda from port group i3c0 to this pad." }
                      { value: "7", name: "port_i3c1_puc", desc: "Connect port puc from port group i3c1 to this pad." }
                      { value: "8", name: "port_i3c1_scl", desc: "Connect port scl from port group i3c1 to this pad." }
                      { value: "9", name: "port_i3c1_sda", desc: "Connect port sda from port group i3c1 to this pad." }
                      { value: "10", name: "port_qspim0_csn0", desc: "Connect port csn0 from port group qspim0 to this pad." }
                      { value: "11", name: "port_qspim0_csn1", desc: "Connect port csn1 from port group qspim0 to this pad." }
                      { value: "12", name: "port_qspim0_csn2", desc: "Connect port csn2 from port group qspim0 to this pad." }
                      { value: "13", name: "port_qspim0_csn3", desc: "Connect port csn3 from port group qspim0 to this pad." }
                      { value: "14", name: "port_qspim0_sck", desc: "Connect port sck from port group qspim0 to this pad." }
                      { value: "15", name: "port_qspim0_sdio0", desc: "Connect port sdio0 from port group qspim0 to this pad." }
                      { value: "16", name: "port_qspim0_sdio1", desc: "Connect port sdio1 from port group qspim0 to this pad." }
                      { value: "17", name: "port_qspim0_sdio2", desc: "Connect port sdio2 from port group qspim0 to this pad." }
                      { value: "18", name: "port_qspim0_sdio3", desc: "Connect port sdio3 from port group qspim0 to this pad." }
                      { value: "19", name: "port_qspis0_csn", desc: "Connect port csn from port group qspis0 to this pad." }
                      { value: "20", name: "port_qspis0_sck", desc: "Connect port sck from port group qspis0 to this pad." }
                      { value: "21", name: "port_qspis0_sdio0", desc: "Connect port sdio0 from port group qspis0 to this pad." }
                      { value: "22", name: "port_qspis0_sdio1", desc: "Connect port sdio1 from port group qspis0 to this pad." }
                      { value: "23", name: "port_qspis0_sdio2", desc: "Connect port sdio2 from port group qspis0 to this pad." }
                      { value: "24", name: "port_qspis0_sdio3", desc: "Connect port sdio3 from port group qspis0 to this pad." }
                      { value: "25", name: "port_uart0_rx", desc: "Connect port rx from port group uart0 to this pad." }
                      { value: "26", name: "port_uart0_tx", desc: "Connect port tx from port group uart0 to this pad." }
                  ]
              }
          ]
      }

      {
          name: PAD_GPIO30_CFG
          desc: '''
            Pad signal configuration.
          '''
          swaccess: "rw"
          fields: [
            {
                bits: "0"
                name: chip2pad
                desc: '''
                     Connects to pad's TX driver
                '''
                swaccess: "rw"
                hwaccess: "hro"
                resval: "0"
            },
            {
                bits: "1"
                name: drv0
                desc: '''
                     Choose the driving strength of the pad. LSB = ~3mA
                '''
                swaccess: "rw"
                hwaccess: "hro"
                resval: "0"
            },
            {
                bits: "2"
                name: drv1
                desc: '''
                     Choose the driving strength of the pad. LSB = ~3mA
                '''
                swaccess: "rw"
                hwaccess: "hro"
                resval: "0"
            },
            {
                bits: "3"
                name: drv2
                desc: '''
                     Choose the driving strength of the pad. LSB = ~3mA
                '''
                swaccess: "rw"
                hwaccess: "hro"
                resval: "0"
            },
            {
                bits: "4"
                name: drv3
                desc: '''
                     Choose the driving strength of the pad. LSB = ~3mA
                '''
                swaccess: "rw"
                hwaccess: "hro"
                resval: "1"
            },
            {
                bits: "5"
                name: pull_en
                desc: '''
                     Enable pull up/down (depends on pull_sel) resistor, active-high
                '''
                swaccess: "rw"
                hwaccess: "hro"
                resval: "0"
            },
            {
                bits: "6"
                name: pull_sel
                desc: '''
                     1 -> use pull-up resistor (if pull_en == 1), 0 -> use pull-down resistor
                '''
                swaccess: "rw"
                hwaccess: "hro"
                resval: "0"
            },
            {
                bits: "7"
                name: ret_en
                desc: '''
                     Enable retention mode, active-high
                '''
                swaccess: "rw"
                hwaccess: "hro"
                resval: "0"
            },
            {
                bits: "8"
                name: st_en
                desc: '''
                     Schmitt-trigger enable, active high
                '''
                swaccess: "rw"
                hwaccess: "hro"
                resval: "0"
            },
            {
                bits: "9"
                name: tx_en
                desc: '''
                     TX driver enable, active low
                '''
                swaccess: "rw"
                hwaccess: "hro"
                resval: "0"
            },
          ]
      }

       {
          name: PAD_GPIO30_MUX_SEL
          desc: '''
              Pad signal port multiplex selection for pad pad_gpio30. The programmed value defines which port
              is connected to the pad.
          '''
          swaccess: "rw"
          hwaccess: "hro"
          resval: 0
          fields: [
              {
                  bits: "4:0"
                  enum: [
                      { value: "0", name: "register", desc: "Connects the Pad to the internal configuration register."}
                      { value: "1", name: "port_gpio_gpio30", desc: "Connect port gpio30 from port group gpio to this pad." }
                      { value: "2", name: "port_i2c0_scl", desc: "Connect port scl from port group i2c0 to this pad." }
                      { value: "3", name: "port_i2c0_sda", desc: "Connect port sda from port group i2c0 to this pad." }
                      { value: "4", name: "port_i3c0_puc", desc: "Connect port puc from port group i3c0 to this pad." }
                      { value: "5", name: "port_i3c0_scl", desc: "Connect port scl from port group i3c0 to this pad." }
                      { value: "6", name: "port_i3c0_sda", desc: "Connect port sda from port group i3c0 to this pad." }
                      { value: "7", name: "port_i3c1_puc", desc: "Connect port puc from port group i3c1 to this pad." }
                      { value: "8", name: "port_i3c1_scl", desc: "Connect port scl from port group i3c1 to this pad." }
                      { value: "9", name: "port_i3c1_sda", desc: "Connect port sda from port group i3c1 to this pad." }
                      { value: "10", name: "port_qspim0_csn0", desc: "Connect port csn0 from port group qspim0 to this pad." }
                      { value: "11", name: "port_qspim0_csn1", desc: "Connect port csn1 from port group qspim0 to this pad." }
                      { value: "12", name: "port_qspim0_csn2", desc: "Connect port csn2 from port group qspim0 to this pad." }
                      { value: "13", name: "port_qspim0_csn3", desc: "Connect port csn3 from port group qspim0 to this pad." }
                      { value: "14", name: "port_qspim0_sck", desc: "Connect port sck from port group qspim0 to this pad." }
                      { value: "15", name: "port_qspim0_sdio0", desc: "Connect port sdio0 from port group qspim0 to this pad." }
                      { value: "16", name: "port_qspim0_sdio1", desc: "Connect port sdio1 from port group qspim0 to this pad." }
                      { value: "17", name: "port_qspim0_sdio2", desc: "Connect port sdio2 from port group qspim0 to this pad." }
                      { value: "18", name: "port_qspim0_sdio3", desc: "Connect port sdio3 from port group qspim0 to this pad." }
                      { value: "19", name: "port_qspis0_csn", desc: "Connect port csn from port group qspis0 to this pad." }
                      { value: "20", name: "port_qspis0_sck", desc: "Connect port sck from port group qspis0 to this pad." }
                      { value: "21", name: "port_qspis0_sdio0", desc: "Connect port sdio0 from port group qspis0 to this pad." }
                      { value: "22", name: "port_qspis0_sdio1", desc: "Connect port sdio1 from port group qspis0 to this pad." }
                      { value: "23", name: "port_qspis0_sdio2", desc: "Connect port sdio2 from port group qspis0 to this pad." }
                      { value: "24", name: "port_qspis0_sdio3", desc: "Connect port sdio3 from port group qspis0 to this pad." }
                      { value: "25", name: "port_uart0_rx", desc: "Connect port rx from port group uart0 to this pad." }
                      { value: "26", name: "port_uart0_tx", desc: "Connect port tx from port group uart0 to this pad." }
                  ]
              }
          ]
      }

      {
          name: PAD_GPIO31_CFG
          desc: '''
            Pad signal configuration.
          '''
          swaccess: "rw"
          fields: [
            {
                bits: "0"
                name: chip2pad
                desc: '''
                     Connects to pad's TX driver
                '''
                swaccess: "rw"
                hwaccess: "hro"
                resval: "0"
            },
            {
                bits: "1"
                name: drv0
                desc: '''
                     Choose the driving strength of the pad. LSB = ~3mA
                '''
                swaccess: "rw"
                hwaccess: "hro"
                resval: "0"
            },
            {
                bits: "2"
                name: drv1
                desc: '''
                     Choose the driving strength of the pad. LSB = ~3mA
                '''
                swaccess: "rw"
                hwaccess: "hro"
                resval: "0"
            },
            {
                bits: "3"
                name: drv2
                desc: '''
                     Choose the driving strength of the pad. LSB = ~3mA
                '''
                swaccess: "rw"
                hwaccess: "hro"
                resval: "0"
            },
            {
                bits: "4"
                name: drv3
                desc: '''
                     Choose the driving strength of the pad. LSB = ~3mA
                '''
                swaccess: "rw"
                hwaccess: "hro"
                resval: "1"
            },
            {
                bits: "5"
                name: pull_en
                desc: '''
                     Enable pull up/down (depends on pull_sel) resistor, active-high
                '''
                swaccess: "rw"
                hwaccess: "hro"
                resval: "0"
            },
            {
                bits: "6"
                name: pull_sel
                desc: '''
                     1 -> use pull-up resistor (if pull_en == 1), 0 -> use pull-down resistor
                '''
                swaccess: "rw"
                hwaccess: "hro"
                resval: "0"
            },
            {
                bits: "7"
                name: ret_en
                desc: '''
                     Enable retention mode, active-high
                '''
                swaccess: "rw"
                hwaccess: "hro"
                resval: "0"
            },
            {
                bits: "8"
                name: st_en
                desc: '''
                     Schmitt-trigger enable, active high
                '''
                swaccess: "rw"
                hwaccess: "hro"
                resval: "0"
            },
            {
                bits: "9"
                name: tx_en
                desc: '''
                     TX driver enable, active low
                '''
                swaccess: "rw"
                hwaccess: "hro"
                resval: "0"
            },
          ]
      }

       {
          name: PAD_GPIO31_MUX_SEL
          desc: '''
              Pad signal port multiplex selection for pad pad_gpio31. The programmed value defines which port
              is connected to the pad.
          '''
          swaccess: "rw"
          hwaccess: "hro"
          resval: 0
          fields: [
              {
                  bits: "4:0"
                  enum: [
                      { value: "0", name: "register", desc: "Connects the Pad to the internal configuration register."}
                      { value: "1", name: "port_gpio_gpio31", desc: "Connect port gpio31 from port group gpio to this pad." }
                      { value: "2", name: "port_i2c0_scl", desc: "Connect port scl from port group i2c0 to this pad." }
                      { value: "3", name: "port_i2c0_sda", desc: "Connect port sda from port group i2c0 to this pad." }
                      { value: "4", name: "port_i3c0_puc", desc: "Connect port puc from port group i3c0 to this pad." }
                      { value: "5", name: "port_i3c0_scl", desc: "Connect port scl from port group i3c0 to this pad." }
                      { value: "6", name: "port_i3c0_sda", desc: "Connect port sda from port group i3c0 to this pad." }
                      { value: "7", name: "port_i3c1_puc", desc: "Connect port puc from port group i3c1 to this pad." }
                      { value: "8", name: "port_i3c1_scl", desc: "Connect port scl from port group i3c1 to this pad." }
                      { value: "9", name: "port_i3c1_sda", desc: "Connect port sda from port group i3c1 to this pad." }
                      { value: "10", name: "port_qspim0_csn0", desc: "Connect port csn0 from port group qspim0 to this pad." }
                      { value: "11", name: "port_qspim0_csn1", desc: "Connect port csn1 from port group qspim0 to this pad." }
                      { value: "12", name: "port_qspim0_csn2", desc: "Connect port csn2 from port group qspim0 to this pad." }
                      { value: "13", name: "port_qspim0_csn3", desc: "Connect port csn3 from port group qspim0 to this pad." }
                      { value: "14", name: "port_qspim0_sck", desc: "Connect port sck from port group qspim0 to this pad." }
                      { value: "15", name: "port_qspim0_sdio0", desc: "Connect port sdio0 from port group qspim0 to this pad." }
                      { value: "16", name: "port_qspim0_sdio1", desc: "Connect port sdio1 from port group qspim0 to this pad." }
                      { value: "17", name: "port_qspim0_sdio2", desc: "Connect port sdio2 from port group qspim0 to this pad." }
                      { value: "18", name: "port_qspim0_sdio3", desc: "Connect port sdio3 from port group qspim0 to this pad." }
                      { value: "19", name: "port_qspis0_csn", desc: "Connect port csn from port group qspis0 to this pad." }
                      { value: "20", name: "port_qspis0_sck", desc: "Connect port sck from port group qspis0 to this pad." }
                      { value: "21", name: "port_qspis0_sdio0", desc: "Connect port sdio0 from port group qspis0 to this pad." }
                      { value: "22", name: "port_qspis0_sdio1", desc: "Connect port sdio1 from port group qspis0 to this pad." }
                      { value: "23", name: "port_qspis0_sdio2", desc: "Connect port sdio2 from port group qspis0 to this pad." }
                      { value: "24", name: "port_qspis0_sdio3", desc: "Connect port sdio3 from port group qspis0 to this pad." }
                      { value: "25", name: "port_uart0_rx", desc: "Connect port rx from port group uart0 to this pad." }
                      { value: "26", name: "port_uart0_tx", desc: "Connect port tx from port group uart0 to this pad." }
                  ]
              }
          ]
      }

      {
          name: PAD_GPIO32_CFG
          desc: '''
            Pad signal configuration.
          '''
          swaccess: "rw"
          fields: [
            {
                bits: "0"
                name: chip2pad
                desc: '''
                     Connects to pad's TX driver
                '''
                swaccess: "rw"
                hwaccess: "hro"
                resval: "0"
            },
            {
                bits: "1"
                name: drv0
                desc: '''
                     Choose the driving strength of the pad. LSB = ~3mA
                '''
                swaccess: "rw"
                hwaccess: "hro"
                resval: "0"
            },
            {
                bits: "2"
                name: drv1
                desc: '''
                     Choose the driving strength of the pad. LSB = ~3mA
                '''
                swaccess: "rw"
                hwaccess: "hro"
                resval: "0"
            },
            {
                bits: "3"
                name: drv2
                desc: '''
                     Choose the driving strength of the pad. LSB = ~3mA
                '''
                swaccess: "rw"
                hwaccess: "hro"
                resval: "0"
            },
            {
                bits: "4"
                name: drv3
                desc: '''
                     Choose the driving strength of the pad. LSB = ~3mA
                '''
                swaccess: "rw"
                hwaccess: "hro"
                resval: "1"
            },
            {
                bits: "5"
                name: pull_en
                desc: '''
                     Enable pull up/down (depends on pull_sel) resistor, active-high
                '''
                swaccess: "rw"
                hwaccess: "hro"
                resval: "0"
            },
            {
                bits: "6"
                name: pull_sel
                desc: '''
                     1 -> use pull-up resistor (if pull_en == 1), 0 -> use pull-down resistor
                '''
                swaccess: "rw"
                hwaccess: "hro"
                resval: "0"
            },
            {
                bits: "7"
                name: ret_en
                desc: '''
                     Enable retention mode, active-high
                '''
                swaccess: "rw"
                hwaccess: "hro"
                resval: "0"
            },
            {
                bits: "8"
                name: st_en
                desc: '''
                     Schmitt-trigger enable, active high
                '''
                swaccess: "rw"
                hwaccess: "hro"
                resval: "0"
            },
            {
                bits: "9"
                name: tx_en
                desc: '''
                     TX driver enable, active low
                '''
                swaccess: "rw"
                hwaccess: "hro"
                resval: "0"
            },
          ]
      }

       {
          name: PAD_GPIO32_MUX_SEL
          desc: '''
              Pad signal port multiplex selection for pad pad_gpio32. The programmed value defines which port
              is connected to the pad.
          '''
          swaccess: "rw"
          hwaccess: "hro"
          resval: 0
          fields: [
              {
                  bits: "4:0"
                  enum: [
                      { value: "0", name: "register", desc: "Connects the Pad to the internal configuration register."}
                      { value: "1", name: "port_gpio_gpio32", desc: "Connect port gpio32 from port group gpio to this pad." }
                      { value: "2", name: "port_i2c0_scl", desc: "Connect port scl from port group i2c0 to this pad." }
                      { value: "3", name: "port_i2c0_sda", desc: "Connect port sda from port group i2c0 to this pad." }
                      { value: "4", name: "port_i3c0_puc", desc: "Connect port puc from port group i3c0 to this pad." }
                      { value: "5", name: "port_i3c0_scl", desc: "Connect port scl from port group i3c0 to this pad." }
                      { value: "6", name: "port_i3c0_sda", desc: "Connect port sda from port group i3c0 to this pad." }
                      { value: "7", name: "port_i3c1_puc", desc: "Connect port puc from port group i3c1 to this pad." }
                      { value: "8", name: "port_i3c1_scl", desc: "Connect port scl from port group i3c1 to this pad." }
                      { value: "9", name: "port_i3c1_sda", desc: "Connect port sda from port group i3c1 to this pad." }
                      { value: "10", name: "port_qspim0_csn0", desc: "Connect port csn0 from port group qspim0 to this pad." }
                      { value: "11", name: "port_qspim0_csn1", desc: "Connect port csn1 from port group qspim0 to this pad." }
                      { value: "12", name: "port_qspim0_csn2", desc: "Connect port csn2 from port group qspim0 to this pad." }
                      { value: "13", name: "port_qspim0_csn3", desc: "Connect port csn3 from port group qspim0 to this pad." }
                      { value: "14", name: "port_qspim0_sck", desc: "Connect port sck from port group qspim0 to this pad." }
                      { value: "15", name: "port_qspim0_sdio0", desc: "Connect port sdio0 from port group qspim0 to this pad." }
                      { value: "16", name: "port_qspim0_sdio1", desc: "Connect port sdio1 from port group qspim0 to this pad." }
                      { value: "17", name: "port_qspim0_sdio2", desc: "Connect port sdio2 from port group qspim0 to this pad." }
                      { value: "18", name: "port_qspim0_sdio3", desc: "Connect port sdio3 from port group qspim0 to this pad." }
                      { value: "19", name: "port_qspis0_csn", desc: "Connect port csn from port group qspis0 to this pad." }
                      { value: "20", name: "port_qspis0_sck", desc: "Connect port sck from port group qspis0 to this pad." }
                      { value: "21", name: "port_qspis0_sdio0", desc: "Connect port sdio0 from port group qspis0 to this pad." }
                      { value: "22", name: "port_qspis0_sdio1", desc: "Connect port sdio1 from port group qspis0 to this pad." }
                      { value: "23", name: "port_qspis0_sdio2", desc: "Connect port sdio2 from port group qspis0 to this pad." }
                      { value: "24", name: "port_qspis0_sdio3", desc: "Connect port sdio3 from port group qspis0 to this pad." }
                      { value: "25", name: "port_uart0_rx", desc: "Connect port rx from port group uart0 to this pad." }
                      { value: "26", name: "port_uart0_tx", desc: "Connect port tx from port group uart0 to this pad." }
                  ]
              }
          ]
      }

      {
          name: PAD_GPIO33_CFG
          desc: '''
            Pad signal configuration.
          '''
          swaccess: "rw"
          fields: [
            {
                bits: "0"
                name: chip2pad
                desc: '''
                     Connects to pad's TX driver
                '''
                swaccess: "rw"
                hwaccess: "hro"
                resval: "0"
            },
            {
                bits: "1"
                name: drv0
                desc: '''
                     Choose the driving strength of the pad. LSB = ~3mA
                '''
                swaccess: "rw"
                hwaccess: "hro"
                resval: "0"
            },
            {
                bits: "2"
                name: drv1
                desc: '''
                     Choose the driving strength of the pad. LSB = ~3mA
                '''
                swaccess: "rw"
                hwaccess: "hro"
                resval: "0"
            },
            {
                bits: "3"
                name: drv2
                desc: '''
                     Choose the driving strength of the pad. LSB = ~3mA
                '''
                swaccess: "rw"
                hwaccess: "hro"
                resval: "0"
            },
            {
                bits: "4"
                name: drv3
                desc: '''
                     Choose the driving strength of the pad. LSB = ~3mA
                '''
                swaccess: "rw"
                hwaccess: "hro"
                resval: "1"
            },
            {
                bits: "5"
                name: pull_en
                desc: '''
                     Enable pull up/down (depends on pull_sel) resistor, active-high
                '''
                swaccess: "rw"
                hwaccess: "hro"
                resval: "0"
            },
            {
                bits: "6"
                name: pull_sel
                desc: '''
                     1 -> use pull-up resistor (if pull_en == 1), 0 -> use pull-down resistor
                '''
                swaccess: "rw"
                hwaccess: "hro"
                resval: "0"
            },
            {
                bits: "7"
                name: ret_en
                desc: '''
                     Enable retention mode, active-high
                '''
                swaccess: "rw"
                hwaccess: "hro"
                resval: "0"
            },
            {
                bits: "8"
                name: st_en
                desc: '''
                     Schmitt-trigger enable, active high
                '''
                swaccess: "rw"
                hwaccess: "hro"
                resval: "0"
            },
            {
                bits: "9"
                name: tx_en
                desc: '''
                     TX driver enable, active low
                '''
                swaccess: "rw"
                hwaccess: "hro"
                resval: "0"
            },
          ]
      }

       {
          name: PAD_GPIO33_MUX_SEL
          desc: '''
              Pad signal port multiplex selection for pad pad_gpio33. The programmed value defines which port
              is connected to the pad.
          '''
          swaccess: "rw"
          hwaccess: "hro"
          resval: 0
          fields: [
              {
                  bits: "4:0"
                  enum: [
                      { value: "0", name: "register", desc: "Connects the Pad to the internal configuration register."}
                      { value: "1", name: "port_gpio_gpio33", desc: "Connect port gpio33 from port group gpio to this pad." }
                      { value: "2", name: "port_i2c0_scl", desc: "Connect port scl from port group i2c0 to this pad." }
                      { value: "3", name: "port_i2c0_sda", desc: "Connect port sda from port group i2c0 to this pad." }
                      { value: "4", name: "port_i3c0_puc", desc: "Connect port puc from port group i3c0 to this pad." }
                      { value: "5", name: "port_i3c0_scl", desc: "Connect port scl from port group i3c0 to this pad." }
                      { value: "6", name: "port_i3c0_sda", desc: "Connect port sda from port group i3c0 to this pad." }
                      { value: "7", name: "port_i3c1_puc", desc: "Connect port puc from port group i3c1 to this pad." }
                      { value: "8", name: "port_i3c1_scl", desc: "Connect port scl from port group i3c1 to this pad." }
                      { value: "9", name: "port_i3c1_sda", desc: "Connect port sda from port group i3c1 to this pad." }
                      { value: "10", name: "port_qspim0_csn0", desc: "Connect port csn0 from port group qspim0 to this pad." }
                      { value: "11", name: "port_qspim0_csn1", desc: "Connect port csn1 from port group qspim0 to this pad." }
                      { value: "12", name: "port_qspim0_csn2", desc: "Connect port csn2 from port group qspim0 to this pad." }
                      { value: "13", name: "port_qspim0_csn3", desc: "Connect port csn3 from port group qspim0 to this pad." }
                      { value: "14", name: "port_qspim0_sck", desc: "Connect port sck from port group qspim0 to this pad." }
                      { value: "15", name: "port_qspim0_sdio0", desc: "Connect port sdio0 from port group qspim0 to this pad." }
                      { value: "16", name: "port_qspim0_sdio1", desc: "Connect port sdio1 from port group qspim0 to this pad." }
                      { value: "17", name: "port_qspim0_sdio2", desc: "Connect port sdio2 from port group qspim0 to this pad." }
                      { value: "18", name: "port_qspim0_sdio3", desc: "Connect port sdio3 from port group qspim0 to this pad." }
                      { value: "19", name: "port_qspis0_csn", desc: "Connect port csn from port group qspis0 to this pad." }
                      { value: "20", name: "port_qspis0_sck", desc: "Connect port sck from port group qspis0 to this pad." }
                      { value: "21", name: "port_qspis0_sdio0", desc: "Connect port sdio0 from port group qspis0 to this pad." }
                      { value: "22", name: "port_qspis0_sdio1", desc: "Connect port sdio1 from port group qspis0 to this pad." }
                      { value: "23", name: "port_qspis0_sdio2", desc: "Connect port sdio2 from port group qspis0 to this pad." }
                      { value: "24", name: "port_qspis0_sdio3", desc: "Connect port sdio3 from port group qspis0 to this pad." }
                      { value: "25", name: "port_uart0_rx", desc: "Connect port rx from port group uart0 to this pad." }
                      { value: "26", name: "port_uart0_tx", desc: "Connect port tx from port group uart0 to this pad." }
                  ]
              }
          ]
      }

      {
          name: PAD_GPIO34_CFG
          desc: '''
            Pad signal configuration.
          '''
          swaccess: "rw"
          fields: [
            {
                bits: "0"
                name: chip2pad
                desc: '''
                     Connects to pad's TX driver
                '''
                swaccess: "rw"
                hwaccess: "hro"
                resval: "0"
            },
            {
                bits: "1"
                name: drv0
                desc: '''
                     Choose the driving strength of the pad. LSB = ~3mA
                '''
                swaccess: "rw"
                hwaccess: "hro"
                resval: "0"
            },
            {
                bits: "2"
                name: drv1
                desc: '''
                     Choose the driving strength of the pad. LSB = ~3mA
                '''
                swaccess: "rw"
                hwaccess: "hro"
                resval: "0"
            },
            {
                bits: "3"
                name: drv2
                desc: '''
                     Choose the driving strength of the pad. LSB = ~3mA
                '''
                swaccess: "rw"
                hwaccess: "hro"
                resval: "0"
            },
            {
                bits: "4"
                name: drv3
                desc: '''
                     Choose the driving strength of the pad. LSB = ~3mA
                '''
                swaccess: "rw"
                hwaccess: "hro"
                resval: "1"
            },
            {
                bits: "5"
                name: pull_en
                desc: '''
                     Enable pull up/down (depends on pull_sel) resistor, active-high
                '''
                swaccess: "rw"
                hwaccess: "hro"
                resval: "0"
            },
            {
                bits: "6"
                name: pull_sel
                desc: '''
                     1 -> use pull-up resistor (if pull_en == 1), 0 -> use pull-down resistor
                '''
                swaccess: "rw"
                hwaccess: "hro"
                resval: "0"
            },
            {
                bits: "7"
                name: ret_en
                desc: '''
                     Enable retention mode, active-high
                '''
                swaccess: "rw"
                hwaccess: "hro"
                resval: "0"
            },
            {
                bits: "8"
                name: st_en
                desc: '''
                     Schmitt-trigger enable, active high
                '''
                swaccess: "rw"
                hwaccess: "hro"
                resval: "0"
            },
            {
                bits: "9"
                name: tx_en
                desc: '''
                     TX driver enable, active low
                '''
                swaccess: "rw"
                hwaccess: "hro"
                resval: "0"
            },
          ]
      }

       {
          name: PAD_GPIO34_MUX_SEL
          desc: '''
              Pad signal port multiplex selection for pad pad_gpio34. The programmed value defines which port
              is connected to the pad.
          '''
          swaccess: "rw"
          hwaccess: "hro"
          resval: 0
          fields: [
              {
                  bits: "4:0"
                  enum: [
                      { value: "0", name: "register", desc: "Connects the Pad to the internal configuration register."}
                      { value: "1", name: "port_gpio_gpio34", desc: "Connect port gpio34 from port group gpio to this pad." }
                      { value: "2", name: "port_i2c0_scl", desc: "Connect port scl from port group i2c0 to this pad." }
                      { value: "3", name: "port_i2c0_sda", desc: "Connect port sda from port group i2c0 to this pad." }
                      { value: "4", name: "port_i3c0_puc", desc: "Connect port puc from port group i3c0 to this pad." }
                      { value: "5", name: "port_i3c0_scl", desc: "Connect port scl from port group i3c0 to this pad." }
                      { value: "6", name: "port_i3c0_sda", desc: "Connect port sda from port group i3c0 to this pad." }
                      { value: "7", name: "port_i3c1_puc", desc: "Connect port puc from port group i3c1 to this pad." }
                      { value: "8", name: "port_i3c1_scl", desc: "Connect port scl from port group i3c1 to this pad." }
                      { value: "9", name: "port_i3c1_sda", desc: "Connect port sda from port group i3c1 to this pad." }
                      { value: "10", name: "port_qspim0_csn0", desc: "Connect port csn0 from port group qspim0 to this pad." }
                      { value: "11", name: "port_qspim0_csn1", desc: "Connect port csn1 from port group qspim0 to this pad." }
                      { value: "12", name: "port_qspim0_csn2", desc: "Connect port csn2 from port group qspim0 to this pad." }
                      { value: "13", name: "port_qspim0_csn3", desc: "Connect port csn3 from port group qspim0 to this pad." }
                      { value: "14", name: "port_qspim0_sck", desc: "Connect port sck from port group qspim0 to this pad." }
                      { value: "15", name: "port_qspim0_sdio0", desc: "Connect port sdio0 from port group qspim0 to this pad." }
                      { value: "16", name: "port_qspim0_sdio1", desc: "Connect port sdio1 from port group qspim0 to this pad." }
                      { value: "17", name: "port_qspim0_sdio2", desc: "Connect port sdio2 from port group qspim0 to this pad." }
                      { value: "18", name: "port_qspim0_sdio3", desc: "Connect port sdio3 from port group qspim0 to this pad." }
                      { value: "19", name: "port_qspis0_csn", desc: "Connect port csn from port group qspis0 to this pad." }
                      { value: "20", name: "port_qspis0_sck", desc: "Connect port sck from port group qspis0 to this pad." }
                      { value: "21", name: "port_qspis0_sdio0", desc: "Connect port sdio0 from port group qspis0 to this pad." }
                      { value: "22", name: "port_qspis0_sdio1", desc: "Connect port sdio1 from port group qspis0 to this pad." }
                      { value: "23", name: "port_qspis0_sdio2", desc: "Connect port sdio2 from port group qspis0 to this pad." }
                      { value: "24", name: "port_qspis0_sdio3", desc: "Connect port sdio3 from port group qspis0 to this pad." }
                      { value: "25", name: "port_uart0_rx", desc: "Connect port rx from port group uart0 to this pad." }
                      { value: "26", name: "port_uart0_tx", desc: "Connect port tx from port group uart0 to this pad." }
                  ]
              }
          ]
      }

      {
          name: PAD_GPIO35_CFG
          desc: '''
            Pad signal configuration.
          '''
          swaccess: "rw"
          fields: [
            {
                bits: "0"
                name: chip2pad
                desc: '''
                     Connects to pad's TX driver
                '''
                swaccess: "rw"
                hwaccess: "hro"
                resval: "0"
            },
            {
                bits: "1"
                name: drv0
                desc: '''
                     Choose the driving strength of the pad. LSB = ~3mA
                '''
                swaccess: "rw"
                hwaccess: "hro"
                resval: "0"
            },
            {
                bits: "2"
                name: drv1
                desc: '''
                     Choose the driving strength of the pad. LSB = ~3mA
                '''
                swaccess: "rw"
                hwaccess: "hro"
                resval: "0"
            },
            {
                bits: "3"
                name: drv2
                desc: '''
                     Choose the driving strength of the pad. LSB = ~3mA
                '''
                swaccess: "rw"
                hwaccess: "hro"
                resval: "0"
            },
            {
                bits: "4"
                name: drv3
                desc: '''
                     Choose the driving strength of the pad. LSB = ~3mA
                '''
                swaccess: "rw"
                hwaccess: "hro"
                resval: "1"
            },
            {
                bits: "5"
                name: pull_en
                desc: '''
                     Enable pull up/down (depends on pull_sel) resistor, active-high
                '''
                swaccess: "rw"
                hwaccess: "hro"
                resval: "0"
            },
            {
                bits: "6"
                name: pull_sel
                desc: '''
                     1 -> use pull-up resistor (if pull_en == 1), 0 -> use pull-down resistor
                '''
                swaccess: "rw"
                hwaccess: "hro"
                resval: "0"
            },
            {
                bits: "7"
                name: ret_en
                desc: '''
                     Enable retention mode, active-high
                '''
                swaccess: "rw"
                hwaccess: "hro"
                resval: "0"
            },
            {
                bits: "8"
                name: st_en
                desc: '''
                     Schmitt-trigger enable, active high
                '''
                swaccess: "rw"
                hwaccess: "hro"
                resval: "0"
            },
            {
                bits: "9"
                name: tx_en
                desc: '''
                     TX driver enable, active low
                '''
                swaccess: "rw"
                hwaccess: "hro"
                resval: "0"
            },
          ]
      }

       {
          name: PAD_GPIO35_MUX_SEL
          desc: '''
              Pad signal port multiplex selection for pad pad_gpio35. The programmed value defines which port
              is connected to the pad.
          '''
          swaccess: "rw"
          hwaccess: "hro"
          resval: 0
          fields: [
              {
                  bits: "4:0"
                  enum: [
                      { value: "0", name: "register", desc: "Connects the Pad to the internal configuration register."}
                      { value: "1", name: "port_gpio_gpio35", desc: "Connect port gpio35 from port group gpio to this pad." }
                      { value: "2", name: "port_i2c0_scl", desc: "Connect port scl from port group i2c0 to this pad." }
                      { value: "3", name: "port_i2c0_sda", desc: "Connect port sda from port group i2c0 to this pad." }
                      { value: "4", name: "port_i3c0_puc", desc: "Connect port puc from port group i3c0 to this pad." }
                      { value: "5", name: "port_i3c0_scl", desc: "Connect port scl from port group i3c0 to this pad." }
                      { value: "6", name: "port_i3c0_sda", desc: "Connect port sda from port group i3c0 to this pad." }
                      { value: "7", name: "port_i3c1_puc", desc: "Connect port puc from port group i3c1 to this pad." }
                      { value: "8", name: "port_i3c1_scl", desc: "Connect port scl from port group i3c1 to this pad." }
                      { value: "9", name: "port_i3c1_sda", desc: "Connect port sda from port group i3c1 to this pad." }
                      { value: "10", name: "port_qspim0_csn0", desc: "Connect port csn0 from port group qspim0 to this pad." }
                      { value: "11", name: "port_qspim0_csn1", desc: "Connect port csn1 from port group qspim0 to this pad." }
                      { value: "12", name: "port_qspim0_csn2", desc: "Connect port csn2 from port group qspim0 to this pad." }
                      { value: "13", name: "port_qspim0_csn3", desc: "Connect port csn3 from port group qspim0 to this pad." }
                      { value: "14", name: "port_qspim0_sck", desc: "Connect port sck from port group qspim0 to this pad." }
                      { value: "15", name: "port_qspim0_sdio0", desc: "Connect port sdio0 from port group qspim0 to this pad." }
                      { value: "16", name: "port_qspim0_sdio1", desc: "Connect port sdio1 from port group qspim0 to this pad." }
                      { value: "17", name: "port_qspim0_sdio2", desc: "Connect port sdio2 from port group qspim0 to this pad." }
                      { value: "18", name: "port_qspim0_sdio3", desc: "Connect port sdio3 from port group qspim0 to this pad." }
                      { value: "19", name: "port_qspis0_csn", desc: "Connect port csn from port group qspis0 to this pad." }
                      { value: "20", name: "port_qspis0_sck", desc: "Connect port sck from port group qspis0 to this pad." }
                      { value: "21", name: "port_qspis0_sdio0", desc: "Connect port sdio0 from port group qspis0 to this pad." }
                      { value: "22", name: "port_qspis0_sdio1", desc: "Connect port sdio1 from port group qspis0 to this pad." }
                      { value: "23", name: "port_qspis0_sdio2", desc: "Connect port sdio2 from port group qspis0 to this pad." }
                      { value: "24", name: "port_qspis0_sdio3", desc: "Connect port sdio3 from port group qspis0 to this pad." }
                      { value: "25", name: "port_uart0_rx", desc: "Connect port rx from port group uart0 to this pad." }
                      { value: "26", name: "port_uart0_tx", desc: "Connect port tx from port group uart0 to this pad." }
                  ]
              }
          ]
      }

      {
          name: PAD_GPIO36_CFG
          desc: '''
            Pad signal configuration.
          '''
          swaccess: "rw"
          fields: [
            {
                bits: "0"
                name: chip2pad
                desc: '''
                     Connects to pad's TX driver
                '''
                swaccess: "rw"
                hwaccess: "hro"
                resval: "0"
            },
            {
                bits: "1"
                name: drv0
                desc: '''
                     Choose the driving strength of the pad. LSB = ~3mA
                '''
                swaccess: "rw"
                hwaccess: "hro"
                resval: "0"
            },
            {
                bits: "2"
                name: drv1
                desc: '''
                     Choose the driving strength of the pad. LSB = ~3mA
                '''
                swaccess: "rw"
                hwaccess: "hro"
                resval: "0"
            },
            {
                bits: "3"
                name: drv2
                desc: '''
                     Choose the driving strength of the pad. LSB = ~3mA
                '''
                swaccess: "rw"
                hwaccess: "hro"
                resval: "0"
            },
            {
                bits: "4"
                name: drv3
                desc: '''
                     Choose the driving strength of the pad. LSB = ~3mA
                '''
                swaccess: "rw"
                hwaccess: "hro"
                resval: "1"
            },
            {
                bits: "5"
                name: pull_en
                desc: '''
                     Enable pull up/down (depends on pull_sel) resistor, active-high
                '''
                swaccess: "rw"
                hwaccess: "hro"
                resval: "0"
            },
            {
                bits: "6"
                name: pull_sel
                desc: '''
                     1 -> use pull-up resistor (if pull_en == 1), 0 -> use pull-down resistor
                '''
                swaccess: "rw"
                hwaccess: "hro"
                resval: "0"
            },
            {
                bits: "7"
                name: ret_en
                desc: '''
                     Enable retention mode, active-high
                '''
                swaccess: "rw"
                hwaccess: "hro"
                resval: "0"
            },
            {
                bits: "8"
                name: st_en
                desc: '''
                     Schmitt-trigger enable, active high
                '''
                swaccess: "rw"
                hwaccess: "hro"
                resval: "0"
            },
            {
                bits: "9"
                name: tx_en
                desc: '''
                     TX driver enable, active low
                '''
                swaccess: "rw"
                hwaccess: "hro"
                resval: "0"
            },
          ]
      }

       {
          name: PAD_GPIO36_MUX_SEL
          desc: '''
              Pad signal port multiplex selection for pad pad_gpio36. The programmed value defines which port
              is connected to the pad.
          '''
          swaccess: "rw"
          hwaccess: "hro"
          resval: 0
          fields: [
              {
                  bits: "4:0"
                  enum: [
                      { value: "0", name: "register", desc: "Connects the Pad to the internal configuration register."}
                      { value: "1", name: "port_gpio_gpio36", desc: "Connect port gpio36 from port group gpio to this pad." }
                      { value: "2", name: "port_i2c0_scl", desc: "Connect port scl from port group i2c0 to this pad." }
                      { value: "3", name: "port_i2c0_sda", desc: "Connect port sda from port group i2c0 to this pad." }
                      { value: "4", name: "port_i3c0_puc", desc: "Connect port puc from port group i3c0 to this pad." }
                      { value: "5", name: "port_i3c0_scl", desc: "Connect port scl from port group i3c0 to this pad." }
                      { value: "6", name: "port_i3c0_sda", desc: "Connect port sda from port group i3c0 to this pad." }
                      { value: "7", name: "port_i3c1_puc", desc: "Connect port puc from port group i3c1 to this pad." }
                      { value: "8", name: "port_i3c1_scl", desc: "Connect port scl from port group i3c1 to this pad." }
                      { value: "9", name: "port_i3c1_sda", desc: "Connect port sda from port group i3c1 to this pad." }
                      { value: "10", name: "port_qspim0_csn0", desc: "Connect port csn0 from port group qspim0 to this pad." }
                      { value: "11", name: "port_qspim0_csn1", desc: "Connect port csn1 from port group qspim0 to this pad." }
                      { value: "12", name: "port_qspim0_csn2", desc: "Connect port csn2 from port group qspim0 to this pad." }
                      { value: "13", name: "port_qspim0_csn3", desc: "Connect port csn3 from port group qspim0 to this pad." }
                      { value: "14", name: "port_qspim0_sck", desc: "Connect port sck from port group qspim0 to this pad." }
                      { value: "15", name: "port_qspim0_sdio0", desc: "Connect port sdio0 from port group qspim0 to this pad." }
                      { value: "16", name: "port_qspim0_sdio1", desc: "Connect port sdio1 from port group qspim0 to this pad." }
                      { value: "17", name: "port_qspim0_sdio2", desc: "Connect port sdio2 from port group qspim0 to this pad." }
                      { value: "18", name: "port_qspim0_sdio3", desc: "Connect port sdio3 from port group qspim0 to this pad." }
                      { value: "19", name: "port_qspis0_csn", desc: "Connect port csn from port group qspis0 to this pad." }
                      { value: "20", name: "port_qspis0_sck", desc: "Connect port sck from port group qspis0 to this pad." }
                      { value: "21", name: "port_qspis0_sdio0", desc: "Connect port sdio0 from port group qspis0 to this pad." }
                      { value: "22", name: "port_qspis0_sdio1", desc: "Connect port sdio1 from port group qspis0 to this pad." }
                      { value: "23", name: "port_qspis0_sdio2", desc: "Connect port sdio2 from port group qspis0 to this pad." }
                      { value: "24", name: "port_qspis0_sdio3", desc: "Connect port sdio3 from port group qspis0 to this pad." }
                      { value: "25", name: "port_uart0_rx", desc: "Connect port rx from port group uart0 to this pad." }
                      { value: "26", name: "port_uart0_tx", desc: "Connect port tx from port group uart0 to this pad." }
                  ]
              }
          ]
      }

      {
          name: PAD_GPIO37_CFG
          desc: '''
            Pad signal configuration.
          '''
          swaccess: "rw"
          fields: [
            {
                bits: "0"
                name: chip2pad
                desc: '''
                     Connects to pad's TX driver
                '''
                swaccess: "rw"
                hwaccess: "hro"
                resval: "0"
            },
            {
                bits: "1"
                name: drv0
                desc: '''
                     Choose the driving strength of the pad. LSB = ~3mA
                '''
                swaccess: "rw"
                hwaccess: "hro"
                resval: "0"
            },
            {
                bits: "2"
                name: drv1
                desc: '''
                     Choose the driving strength of the pad. LSB = ~3mA
                '''
                swaccess: "rw"
                hwaccess: "hro"
                resval: "0"
            },
            {
                bits: "3"
                name: drv2
                desc: '''
                     Choose the driving strength of the pad. LSB = ~3mA
                '''
                swaccess: "rw"
                hwaccess: "hro"
                resval: "0"
            },
            {
                bits: "4"
                name: drv3
                desc: '''
                     Choose the driving strength of the pad. LSB = ~3mA
                '''
                swaccess: "rw"
                hwaccess: "hro"
                resval: "1"
            },
            {
                bits: "5"
                name: pull_en
                desc: '''
                     Enable pull up/down (depends on pull_sel) resistor, active-high
                '''
                swaccess: "rw"
                hwaccess: "hro"
                resval: "0"
            },
            {
                bits: "6"
                name: pull_sel
                desc: '''
                     1 -> use pull-up resistor (if pull_en == 1), 0 -> use pull-down resistor
                '''
                swaccess: "rw"
                hwaccess: "hro"
                resval: "0"
            },
            {
                bits: "7"
                name: ret_en
                desc: '''
                     Enable retention mode, active-high
                '''
                swaccess: "rw"
                hwaccess: "hro"
                resval: "0"
            },
            {
                bits: "8"
                name: st_en
                desc: '''
                     Schmitt-trigger enable, active high
                '''
                swaccess: "rw"
                hwaccess: "hro"
                resval: "0"
            },
            {
                bits: "9"
                name: tx_en
                desc: '''
                     TX driver enable, active low
                '''
                swaccess: "rw"
                hwaccess: "hro"
                resval: "0"
            },
          ]
      }

       {
          name: PAD_GPIO37_MUX_SEL
          desc: '''
              Pad signal port multiplex selection for pad pad_gpio37. The programmed value defines which port
              is connected to the pad.
          '''
          swaccess: "rw"
          hwaccess: "hro"
          resval: 0
          fields: [
              {
                  bits: "4:0"
                  enum: [
                      { value: "0", name: "register", desc: "Connects the Pad to the internal configuration register."}
                      { value: "1", name: "port_gpio_gpio37", desc: "Connect port gpio37 from port group gpio to this pad." }
                      { value: "2", name: "port_i2c0_scl", desc: "Connect port scl from port group i2c0 to this pad." }
                      { value: "3", name: "port_i2c0_sda", desc: "Connect port sda from port group i2c0 to this pad." }
                      { value: "4", name: "port_i3c0_puc", desc: "Connect port puc from port group i3c0 to this pad." }
                      { value: "5", name: "port_i3c0_scl", desc: "Connect port scl from port group i3c0 to this pad." }
                      { value: "6", name: "port_i3c0_sda", desc: "Connect port sda from port group i3c0 to this pad." }
                      { value: "7", name: "port_i3c1_puc", desc: "Connect port puc from port group i3c1 to this pad." }
                      { value: "8", name: "port_i3c1_scl", desc: "Connect port scl from port group i3c1 to this pad." }
                      { value: "9", name: "port_i3c1_sda", desc: "Connect port sda from port group i3c1 to this pad." }
                      { value: "10", name: "port_qspim0_csn0", desc: "Connect port csn0 from port group qspim0 to this pad." }
                      { value: "11", name: "port_qspim0_csn1", desc: "Connect port csn1 from port group qspim0 to this pad." }
                      { value: "12", name: "port_qspim0_csn2", desc: "Connect port csn2 from port group qspim0 to this pad." }
                      { value: "13", name: "port_qspim0_csn3", desc: "Connect port csn3 from port group qspim0 to this pad." }
                      { value: "14", name: "port_qspim0_sck", desc: "Connect port sck from port group qspim0 to this pad." }
                      { value: "15", name: "port_qspim0_sdio0", desc: "Connect port sdio0 from port group qspim0 to this pad." }
                      { value: "16", name: "port_qspim0_sdio1", desc: "Connect port sdio1 from port group qspim0 to this pad." }
                      { value: "17", name: "port_qspim0_sdio2", desc: "Connect port sdio2 from port group qspim0 to this pad." }
                      { value: "18", name: "port_qspim0_sdio3", desc: "Connect port sdio3 from port group qspim0 to this pad." }
                      { value: "19", name: "port_qspis0_csn", desc: "Connect port csn from port group qspis0 to this pad." }
                      { value: "20", name: "port_qspis0_sck", desc: "Connect port sck from port group qspis0 to this pad." }
                      { value: "21", name: "port_qspis0_sdio0", desc: "Connect port sdio0 from port group qspis0 to this pad." }
                      { value: "22", name: "port_qspis0_sdio1", desc: "Connect port sdio1 from port group qspis0 to this pad." }
                      { value: "23", name: "port_qspis0_sdio2", desc: "Connect port sdio2 from port group qspis0 to this pad." }
                      { value: "24", name: "port_qspis0_sdio3", desc: "Connect port sdio3 from port group qspis0 to this pad." }
                      { value: "25", name: "port_uart0_rx", desc: "Connect port rx from port group uart0 to this pad." }
                      { value: "26", name: "port_uart0_tx", desc: "Connect port tx from port group uart0 to this pad." }
                  ]
              }
          ]
      }

      {
          name: PAD_GPIO38_CFG
          desc: '''
            Pad signal configuration.
          '''
          swaccess: "rw"
          fields: [
            {
                bits: "0"
                name: chip2pad
                desc: '''
                     Connects to pad's TX driver
                '''
                swaccess: "rw"
                hwaccess: "hro"
                resval: "0"
            },
            {
                bits: "1"
                name: drv0
                desc: '''
                     Choose the driving strength of the pad. LSB = ~3mA
                '''
                swaccess: "rw"
                hwaccess: "hro"
                resval: "0"
            },
            {
                bits: "2"
                name: drv1
                desc: '''
                     Choose the driving strength of the pad. LSB = ~3mA
                '''
                swaccess: "rw"
                hwaccess: "hro"
                resval: "0"
            },
            {
                bits: "3"
                name: drv2
                desc: '''
                     Choose the driving strength of the pad. LSB = ~3mA
                '''
                swaccess: "rw"
                hwaccess: "hro"
                resval: "0"
            },
            {
                bits: "4"
                name: drv3
                desc: '''
                     Choose the driving strength of the pad. LSB = ~3mA
                '''
                swaccess: "rw"
                hwaccess: "hro"
                resval: "1"
            },
            {
                bits: "5"
                name: pull_en
                desc: '''
                     Enable pull up/down (depends on pull_sel) resistor, active-high
                '''
                swaccess: "rw"
                hwaccess: "hro"
                resval: "0"
            },
            {
                bits: "6"
                name: pull_sel
                desc: '''
                     1 -> use pull-up resistor (if pull_en == 1), 0 -> use pull-down resistor
                '''
                swaccess: "rw"
                hwaccess: "hro"
                resval: "0"
            },
            {
                bits: "7"
                name: ret_en
                desc: '''
                     Enable retention mode, active-high
                '''
                swaccess: "rw"
                hwaccess: "hro"
                resval: "0"
            },
            {
                bits: "8"
                name: st_en
                desc: '''
                     Schmitt-trigger enable, active high
                '''
                swaccess: "rw"
                hwaccess: "hro"
                resval: "0"
            },
            {
                bits: "9"
                name: tx_en
                desc: '''
                     TX driver enable, active low
                '''
                swaccess: "rw"
                hwaccess: "hro"
                resval: "0"
            },
          ]
      }

       {
          name: PAD_GPIO38_MUX_SEL
          desc: '''
              Pad signal port multiplex selection for pad pad_gpio38. The programmed value defines which port
              is connected to the pad.
          '''
          swaccess: "rw"
          hwaccess: "hro"
          resval: 0
          fields: [
              {
                  bits: "4:0"
                  enum: [
                      { value: "0", name: "register", desc: "Connects the Pad to the internal configuration register."}
                      { value: "1", name: "port_gpio_gpio38", desc: "Connect port gpio38 from port group gpio to this pad." }
                      { value: "2", name: "port_i2c0_scl", desc: "Connect port scl from port group i2c0 to this pad." }
                      { value: "3", name: "port_i2c0_sda", desc: "Connect port sda from port group i2c0 to this pad." }
                      { value: "4", name: "port_i3c0_puc", desc: "Connect port puc from port group i3c0 to this pad." }
                      { value: "5", name: "port_i3c0_scl", desc: "Connect port scl from port group i3c0 to this pad." }
                      { value: "6", name: "port_i3c0_sda", desc: "Connect port sda from port group i3c0 to this pad." }
                      { value: "7", name: "port_i3c1_puc", desc: "Connect port puc from port group i3c1 to this pad." }
                      { value: "8", name: "port_i3c1_scl", desc: "Connect port scl from port group i3c1 to this pad." }
                      { value: "9", name: "port_i3c1_sda", desc: "Connect port sda from port group i3c1 to this pad." }
                      { value: "10", name: "port_qspim0_csn0", desc: "Connect port csn0 from port group qspim0 to this pad." }
                      { value: "11", name: "port_qspim0_csn1", desc: "Connect port csn1 from port group qspim0 to this pad." }
                      { value: "12", name: "port_qspim0_csn2", desc: "Connect port csn2 from port group qspim0 to this pad." }
                      { value: "13", name: "port_qspim0_csn3", desc: "Connect port csn3 from port group qspim0 to this pad." }
                      { value: "14", name: "port_qspim0_sck", desc: "Connect port sck from port group qspim0 to this pad." }
                      { value: "15", name: "port_qspim0_sdio0", desc: "Connect port sdio0 from port group qspim0 to this pad." }
                      { value: "16", name: "port_qspim0_sdio1", desc: "Connect port sdio1 from port group qspim0 to this pad." }
                      { value: "17", name: "port_qspim0_sdio2", desc: "Connect port sdio2 from port group qspim0 to this pad." }
                      { value: "18", name: "port_qspim0_sdio3", desc: "Connect port sdio3 from port group qspim0 to this pad." }
                      { value: "19", name: "port_qspis0_csn", desc: "Connect port csn from port group qspis0 to this pad." }
                      { value: "20", name: "port_qspis0_sck", desc: "Connect port sck from port group qspis0 to this pad." }
                      { value: "21", name: "port_qspis0_sdio0", desc: "Connect port sdio0 from port group qspis0 to this pad." }
                      { value: "22", name: "port_qspis0_sdio1", desc: "Connect port sdio1 from port group qspis0 to this pad." }
                      { value: "23", name: "port_qspis0_sdio2", desc: "Connect port sdio2 from port group qspis0 to this pad." }
                      { value: "24", name: "port_qspis0_sdio3", desc: "Connect port sdio3 from port group qspis0 to this pad." }
                      { value: "25", name: "port_uart0_rx", desc: "Connect port rx from port group uart0 to this pad." }
                      { value: "26", name: "port_uart0_tx", desc: "Connect port tx from port group uart0 to this pad." }
                  ]
              }
          ]
      }

      {
          name: PAD_GPIO39_CFG
          desc: '''
            Pad signal configuration.
          '''
          swaccess: "rw"
          fields: [
            {
                bits: "0"
                name: chip2pad
                desc: '''
                     Connects to pad's TX driver
                '''
                swaccess: "rw"
                hwaccess: "hro"
                resval: "0"
            },
            {
                bits: "1"
                name: drv0
                desc: '''
                     Choose the driving strength of the pad. LSB = ~3mA
                '''
                swaccess: "rw"
                hwaccess: "hro"
                resval: "0"
            },
            {
                bits: "2"
                name: drv1
                desc: '''
                     Choose the driving strength of the pad. LSB = ~3mA
                '''
                swaccess: "rw"
                hwaccess: "hro"
                resval: "0"
            },
            {
                bits: "3"
                name: drv2
                desc: '''
                     Choose the driving strength of the pad. LSB = ~3mA
                '''
                swaccess: "rw"
                hwaccess: "hro"
                resval: "0"
            },
            {
                bits: "4"
                name: drv3
                desc: '''
                     Choose the driving strength of the pad. LSB = ~3mA
                '''
                swaccess: "rw"
                hwaccess: "hro"
                resval: "1"
            },
            {
                bits: "5"
                name: pull_en
                desc: '''
                     Enable pull up/down (depends on pull_sel) resistor, active-high
                '''
                swaccess: "rw"
                hwaccess: "hro"
                resval: "0"
            },
            {
                bits: "6"
                name: pull_sel
                desc: '''
                     1 -> use pull-up resistor (if pull_en == 1), 0 -> use pull-down resistor
                '''
                swaccess: "rw"
                hwaccess: "hro"
                resval: "0"
            },
            {
                bits: "7"
                name: ret_en
                desc: '''
                     Enable retention mode, active-high
                '''
                swaccess: "rw"
                hwaccess: "hro"
                resval: "0"
            },
            {
                bits: "8"
                name: st_en
                desc: '''
                     Schmitt-trigger enable, active high
                '''
                swaccess: "rw"
                hwaccess: "hro"
                resval: "0"
            },
            {
                bits: "9"
                name: tx_en
                desc: '''
                     TX driver enable, active low
                '''
                swaccess: "rw"
                hwaccess: "hro"
                resval: "0"
            },
          ]
      }

       {
          name: PAD_GPIO39_MUX_SEL
          desc: '''
              Pad signal port multiplex selection for pad pad_gpio39. The programmed value defines which port
              is connected to the pad.
          '''
          swaccess: "rw"
          hwaccess: "hro"
          resval: 0
          fields: [
              {
                  bits: "4:0"
                  enum: [
                      { value: "0", name: "register", desc: "Connects the Pad to the internal configuration register."}
                      { value: "1", name: "port_gpio_gpio39", desc: "Connect port gpio39 from port group gpio to this pad." }
                      { value: "2", name: "port_i2c0_scl", desc: "Connect port scl from port group i2c0 to this pad." }
                      { value: "3", name: "port_i2c0_sda", desc: "Connect port sda from port group i2c0 to this pad." }
                      { value: "4", name: "port_i3c0_puc", desc: "Connect port puc from port group i3c0 to this pad." }
                      { value: "5", name: "port_i3c0_scl", desc: "Connect port scl from port group i3c0 to this pad." }
                      { value: "6", name: "port_i3c0_sda", desc: "Connect port sda from port group i3c0 to this pad." }
                      { value: "7", name: "port_i3c1_puc", desc: "Connect port puc from port group i3c1 to this pad." }
                      { value: "8", name: "port_i3c1_scl", desc: "Connect port scl from port group i3c1 to this pad." }
                      { value: "9", name: "port_i3c1_sda", desc: "Connect port sda from port group i3c1 to this pad." }
                      { value: "10", name: "port_qspim0_csn0", desc: "Connect port csn0 from port group qspim0 to this pad." }
                      { value: "11", name: "port_qspim0_csn1", desc: "Connect port csn1 from port group qspim0 to this pad." }
                      { value: "12", name: "port_qspim0_csn2", desc: "Connect port csn2 from port group qspim0 to this pad." }
                      { value: "13", name: "port_qspim0_csn3", desc: "Connect port csn3 from port group qspim0 to this pad." }
                      { value: "14", name: "port_qspim0_sck", desc: "Connect port sck from port group qspim0 to this pad." }
                      { value: "15", name: "port_qspim0_sdio0", desc: "Connect port sdio0 from port group qspim0 to this pad." }
                      { value: "16", name: "port_qspim0_sdio1", desc: "Connect port sdio1 from port group qspim0 to this pad." }
                      { value: "17", name: "port_qspim0_sdio2", desc: "Connect port sdio2 from port group qspim0 to this pad." }
                      { value: "18", name: "port_qspim0_sdio3", desc: "Connect port sdio3 from port group qspim0 to this pad." }
                      { value: "19", name: "port_qspis0_csn", desc: "Connect port csn from port group qspis0 to this pad." }
                      { value: "20", name: "port_qspis0_sck", desc: "Connect port sck from port group qspis0 to this pad." }
                      { value: "21", name: "port_qspis0_sdio0", desc: "Connect port sdio0 from port group qspis0 to this pad." }
                      { value: "22", name: "port_qspis0_sdio1", desc: "Connect port sdio1 from port group qspis0 to this pad." }
                      { value: "23", name: "port_qspis0_sdio2", desc: "Connect port sdio2 from port group qspis0 to this pad." }
                      { value: "24", name: "port_qspis0_sdio3", desc: "Connect port sdio3 from port group qspis0 to this pad." }
                      { value: "25", name: "port_uart0_rx", desc: "Connect port rx from port group uart0 to this pad." }
                      { value: "26", name: "port_uart0_tx", desc: "Connect port tx from port group uart0 to this pad." }
                  ]
              }
          ]
      }

      {
          name: PAD_GPIO40_CFG
          desc: '''
            Pad signal configuration.
          '''
          swaccess: "rw"
          fields: [
            {
                bits: "0"
                name: chip2pad
                desc: '''
                     Connects to pad's TX driver
                '''
                swaccess: "rw"
                hwaccess: "hro"
                resval: "0"
            },
            {
                bits: "1"
                name: drv0
                desc: '''
                     Choose the driving strength of the pad. LSB = ~3mA
                '''
                swaccess: "rw"
                hwaccess: "hro"
                resval: "0"
            },
            {
                bits: "2"
                name: drv1
                desc: '''
                     Choose the driving strength of the pad. LSB = ~3mA
                '''
                swaccess: "rw"
                hwaccess: "hro"
                resval: "0"
            },
            {
                bits: "3"
                name: drv2
                desc: '''
                     Choose the driving strength of the pad. LSB = ~3mA
                '''
                swaccess: "rw"
                hwaccess: "hro"
                resval: "0"
            },
            {
                bits: "4"
                name: drv3
                desc: '''
                     Choose the driving strength of the pad. LSB = ~3mA
                '''
                swaccess: "rw"
                hwaccess: "hro"
                resval: "1"
            },
            {
                bits: "5"
                name: pull_en
                desc: '''
                     Enable pull up/down (depends on pull_sel) resistor, active-high
                '''
                swaccess: "rw"
                hwaccess: "hro"
                resval: "0"
            },
            {
                bits: "6"
                name: pull_sel
                desc: '''
                     1 -> use pull-up resistor (if pull_en == 1), 0 -> use pull-down resistor
                '''
                swaccess: "rw"
                hwaccess: "hro"
                resval: "0"
            },
            {
                bits: "7"
                name: ret_en
                desc: '''
                     Enable retention mode, active-high
                '''
                swaccess: "rw"
                hwaccess: "hro"
                resval: "0"
            },
            {
                bits: "8"
                name: st_en
                desc: '''
                     Schmitt-trigger enable, active high
                '''
                swaccess: "rw"
                hwaccess: "hro"
                resval: "0"
            },
            {
                bits: "9"
                name: tx_en
                desc: '''
                     TX driver enable, active low
                '''
                swaccess: "rw"
                hwaccess: "hro"
                resval: "0"
            },
          ]
      }

       {
          name: PAD_GPIO40_MUX_SEL
          desc: '''
              Pad signal port multiplex selection for pad pad_gpio40. The programmed value defines which port
              is connected to the pad.
          '''
          swaccess: "rw"
          hwaccess: "hro"
          resval: 0
          fields: [
              {
                  bits: "4:0"
                  enum: [
                      { value: "0", name: "register", desc: "Connects the Pad to the internal configuration register."}
                      { value: "1", name: "port_gpio_gpio40", desc: "Connect port gpio40 from port group gpio to this pad." }
                      { value: "2", name: "port_i2c0_scl", desc: "Connect port scl from port group i2c0 to this pad." }
                      { value: "3", name: "port_i2c0_sda", desc: "Connect port sda from port group i2c0 to this pad." }
                      { value: "4", name: "port_i3c0_puc", desc: "Connect port puc from port group i3c0 to this pad." }
                      { value: "5", name: "port_i3c0_scl", desc: "Connect port scl from port group i3c0 to this pad." }
                      { value: "6", name: "port_i3c0_sda", desc: "Connect port sda from port group i3c0 to this pad." }
                      { value: "7", name: "port_i3c1_puc", desc: "Connect port puc from port group i3c1 to this pad." }
                      { value: "8", name: "port_i3c1_scl", desc: "Connect port scl from port group i3c1 to this pad." }
                      { value: "9", name: "port_i3c1_sda", desc: "Connect port sda from port group i3c1 to this pad." }
                      { value: "10", name: "port_qspim0_csn0", desc: "Connect port csn0 from port group qspim0 to this pad." }
                      { value: "11", name: "port_qspim0_csn1", desc: "Connect port csn1 from port group qspim0 to this pad." }
                      { value: "12", name: "port_qspim0_csn2", desc: "Connect port csn2 from port group qspim0 to this pad." }
                      { value: "13", name: "port_qspim0_csn3", desc: "Connect port csn3 from port group qspim0 to this pad." }
                      { value: "14", name: "port_qspim0_sck", desc: "Connect port sck from port group qspim0 to this pad." }
                      { value: "15", name: "port_qspim0_sdio0", desc: "Connect port sdio0 from port group qspim0 to this pad." }
                      { value: "16", name: "port_qspim0_sdio1", desc: "Connect port sdio1 from port group qspim0 to this pad." }
                      { value: "17", name: "port_qspim0_sdio2", desc: "Connect port sdio2 from port group qspim0 to this pad." }
                      { value: "18", name: "port_qspim0_sdio3", desc: "Connect port sdio3 from port group qspim0 to this pad." }
                      { value: "19", name: "port_qspis0_csn", desc: "Connect port csn from port group qspis0 to this pad." }
                      { value: "20", name: "port_qspis0_sck", desc: "Connect port sck from port group qspis0 to this pad." }
                      { value: "21", name: "port_qspis0_sdio0", desc: "Connect port sdio0 from port group qspis0 to this pad." }
                      { value: "22", name: "port_qspis0_sdio1", desc: "Connect port sdio1 from port group qspis0 to this pad." }
                      { value: "23", name: "port_qspis0_sdio2", desc: "Connect port sdio2 from port group qspis0 to this pad." }
                      { value: "24", name: "port_qspis0_sdio3", desc: "Connect port sdio3 from port group qspis0 to this pad." }
                      { value: "25", name: "port_uart0_rx", desc: "Connect port rx from port group uart0 to this pad." }
                      { value: "26", name: "port_uart0_tx", desc: "Connect port tx from port group uart0 to this pad." }
                  ]
              }
          ]
      }

      {
          name: PAD_GPIO41_CFG
          desc: '''
            Pad signal configuration.
          '''
          swaccess: "rw"
          fields: [
            {
                bits: "0"
                name: chip2pad
                desc: '''
                     Connects to pad's TX driver
                '''
                swaccess: "rw"
                hwaccess: "hro"
                resval: "0"
            },
            {
                bits: "1"
                name: drv0
                desc: '''
                     Choose the driving strength of the pad. LSB = ~3mA
                '''
                swaccess: "rw"
                hwaccess: "hro"
                resval: "0"
            },
            {
                bits: "2"
                name: drv1
                desc: '''
                     Choose the driving strength of the pad. LSB = ~3mA
                '''
                swaccess: "rw"
                hwaccess: "hro"
                resval: "0"
            },
            {
                bits: "3"
                name: drv2
                desc: '''
                     Choose the driving strength of the pad. LSB = ~3mA
                '''
                swaccess: "rw"
                hwaccess: "hro"
                resval: "0"
            },
            {
                bits: "4"
                name: drv3
                desc: '''
                     Choose the driving strength of the pad. LSB = ~3mA
                '''
                swaccess: "rw"
                hwaccess: "hro"
                resval: "1"
            },
            {
                bits: "5"
                name: pull_en
                desc: '''
                     Enable pull up/down (depends on pull_sel) resistor, active-high
                '''
                swaccess: "rw"
                hwaccess: "hro"
                resval: "0"
            },
            {
                bits: "6"
                name: pull_sel
                desc: '''
                     1 -> use pull-up resistor (if pull_en == 1), 0 -> use pull-down resistor
                '''
                swaccess: "rw"
                hwaccess: "hro"
                resval: "0"
            },
            {
                bits: "7"
                name: ret_en
                desc: '''
                     Enable retention mode, active-high
                '''
                swaccess: "rw"
                hwaccess: "hro"
                resval: "0"
            },
            {
                bits: "8"
                name: st_en
                desc: '''
                     Schmitt-trigger enable, active high
                '''
                swaccess: "rw"
                hwaccess: "hro"
                resval: "0"
            },
            {
                bits: "9"
                name: tx_en
                desc: '''
                     TX driver enable, active low
                '''
                swaccess: "rw"
                hwaccess: "hro"
                resval: "0"
            },
          ]
      }

       {
          name: PAD_GPIO41_MUX_SEL
          desc: '''
              Pad signal port multiplex selection for pad pad_gpio41. The programmed value defines which port
              is connected to the pad.
          '''
          swaccess: "rw"
          hwaccess: "hro"
          resval: 0
          fields: [
              {
                  bits: "4:0"
                  enum: [
                      { value: "0", name: "register", desc: "Connects the Pad to the internal configuration register."}
                      { value: "1", name: "port_gpio_gpio41", desc: "Connect port gpio41 from port group gpio to this pad." }
                      { value: "2", name: "port_i2c0_scl", desc: "Connect port scl from port group i2c0 to this pad." }
                      { value: "3", name: "port_i2c0_sda", desc: "Connect port sda from port group i2c0 to this pad." }
                      { value: "4", name: "port_i3c0_puc", desc: "Connect port puc from port group i3c0 to this pad." }
                      { value: "5", name: "port_i3c0_scl", desc: "Connect port scl from port group i3c0 to this pad." }
                      { value: "6", name: "port_i3c0_sda", desc: "Connect port sda from port group i3c0 to this pad." }
                      { value: "7", name: "port_i3c1_puc", desc: "Connect port puc from port group i3c1 to this pad." }
                      { value: "8", name: "port_i3c1_scl", desc: "Connect port scl from port group i3c1 to this pad." }
                      { value: "9", name: "port_i3c1_sda", desc: "Connect port sda from port group i3c1 to this pad." }
                      { value: "10", name: "port_qspim0_csn0", desc: "Connect port csn0 from port group qspim0 to this pad." }
                      { value: "11", name: "port_qspim0_csn1", desc: "Connect port csn1 from port group qspim0 to this pad." }
                      { value: "12", name: "port_qspim0_csn2", desc: "Connect port csn2 from port group qspim0 to this pad." }
                      { value: "13", name: "port_qspim0_csn3", desc: "Connect port csn3 from port group qspim0 to this pad." }
                      { value: "14", name: "port_qspim0_sck", desc: "Connect port sck from port group qspim0 to this pad." }
                      { value: "15", name: "port_qspim0_sdio0", desc: "Connect port sdio0 from port group qspim0 to this pad." }
                      { value: "16", name: "port_qspim0_sdio1", desc: "Connect port sdio1 from port group qspim0 to this pad." }
                      { value: "17", name: "port_qspim0_sdio2", desc: "Connect port sdio2 from port group qspim0 to this pad." }
                      { value: "18", name: "port_qspim0_sdio3", desc: "Connect port sdio3 from port group qspim0 to this pad." }
                      { value: "19", name: "port_qspis0_csn", desc: "Connect port csn from port group qspis0 to this pad." }
                      { value: "20", name: "port_qspis0_sck", desc: "Connect port sck from port group qspis0 to this pad." }
                      { value: "21", name: "port_qspis0_sdio0", desc: "Connect port sdio0 from port group qspis0 to this pad." }
                      { value: "22", name: "port_qspis0_sdio1", desc: "Connect port sdio1 from port group qspis0 to this pad." }
                      { value: "23", name: "port_qspis0_sdio2", desc: "Connect port sdio2 from port group qspis0 to this pad." }
                      { value: "24", name: "port_qspis0_sdio3", desc: "Connect port sdio3 from port group qspis0 to this pad." }
                      { value: "25", name: "port_uart0_rx", desc: "Connect port rx from port group uart0 to this pad." }
                      { value: "26", name: "port_uart0_tx", desc: "Connect port tx from port group uart0 to this pad." }
                  ]
              }
          ]
      }

      {
          name: PAD_GPIO42_CFG
          desc: '''
            Pad signal configuration.
          '''
          swaccess: "rw"
          fields: [
            {
                bits: "0"
                name: chip2pad
                desc: '''
                     Connects to pad's TX driver
                '''
                swaccess: "rw"
                hwaccess: "hro"
                resval: "0"
            },
            {
                bits: "1"
                name: drv0
                desc: '''
                     Choose the driving strength of the pad. LSB = ~3mA
                '''
                swaccess: "rw"
                hwaccess: "hro"
                resval: "0"
            },
            {
                bits: "2"
                name: drv1
                desc: '''
                     Choose the driving strength of the pad. LSB = ~3mA
                '''
                swaccess: "rw"
                hwaccess: "hro"
                resval: "0"
            },
            {
                bits: "3"
                name: drv2
                desc: '''
                     Choose the driving strength of the pad. LSB = ~3mA
                '''
                swaccess: "rw"
                hwaccess: "hro"
                resval: "0"
            },
            {
                bits: "4"
                name: drv3
                desc: '''
                     Choose the driving strength of the pad. LSB = ~3mA
                '''
                swaccess: "rw"
                hwaccess: "hro"
                resval: "1"
            },
            {
                bits: "5"
                name: pull_en
                desc: '''
                     Enable pull up/down (depends on pull_sel) resistor, active-high
                '''
                swaccess: "rw"
                hwaccess: "hro"
                resval: "0"
            },
            {
                bits: "6"
                name: pull_sel
                desc: '''
                     1 -> use pull-up resistor (if pull_en == 1), 0 -> use pull-down resistor
                '''
                swaccess: "rw"
                hwaccess: "hro"
                resval: "0"
            },
            {
                bits: "7"
                name: ret_en
                desc: '''
                     Enable retention mode, active-high
                '''
                swaccess: "rw"
                hwaccess: "hro"
                resval: "0"
            },
            {
                bits: "8"
                name: st_en
                desc: '''
                     Schmitt-trigger enable, active high
                '''
                swaccess: "rw"
                hwaccess: "hro"
                resval: "0"
            },
            {
                bits: "9"
                name: tx_en
                desc: '''
                     TX driver enable, active low
                '''
                swaccess: "rw"
                hwaccess: "hro"
                resval: "0"
            },
          ]
      }

       {
          name: PAD_GPIO42_MUX_SEL
          desc: '''
              Pad signal port multiplex selection for pad pad_gpio42. The programmed value defines which port
              is connected to the pad.
          '''
          swaccess: "rw"
          hwaccess: "hro"
          resval: 0
          fields: [
              {
                  bits: "4:0"
                  enum: [
                      { value: "0", name: "register", desc: "Connects the Pad to the internal configuration register."}
                      { value: "1", name: "port_gpio_gpio42", desc: "Connect port gpio42 from port group gpio to this pad." }
                      { value: "2", name: "port_i2c0_scl", desc: "Connect port scl from port group i2c0 to this pad." }
                      { value: "3", name: "port_i2c0_sda", desc: "Connect port sda from port group i2c0 to this pad." }
                      { value: "4", name: "port_i3c0_puc", desc: "Connect port puc from port group i3c0 to this pad." }
                      { value: "5", name: "port_i3c0_scl", desc: "Connect port scl from port group i3c0 to this pad." }
                      { value: "6", name: "port_i3c0_sda", desc: "Connect port sda from port group i3c0 to this pad." }
                      { value: "7", name: "port_i3c1_puc", desc: "Connect port puc from port group i3c1 to this pad." }
                      { value: "8", name: "port_i3c1_scl", desc: "Connect port scl from port group i3c1 to this pad." }
                      { value: "9", name: "port_i3c1_sda", desc: "Connect port sda from port group i3c1 to this pad." }
                      { value: "10", name: "port_qspim0_csn0", desc: "Connect port csn0 from port group qspim0 to this pad." }
                      { value: "11", name: "port_qspim0_csn1", desc: "Connect port csn1 from port group qspim0 to this pad." }
                      { value: "12", name: "port_qspim0_csn2", desc: "Connect port csn2 from port group qspim0 to this pad." }
                      { value: "13", name: "port_qspim0_csn3", desc: "Connect port csn3 from port group qspim0 to this pad." }
                      { value: "14", name: "port_qspim0_sck", desc: "Connect port sck from port group qspim0 to this pad." }
                      { value: "15", name: "port_qspim0_sdio0", desc: "Connect port sdio0 from port group qspim0 to this pad." }
                      { value: "16", name: "port_qspim0_sdio1", desc: "Connect port sdio1 from port group qspim0 to this pad." }
                      { value: "17", name: "port_qspim0_sdio2", desc: "Connect port sdio2 from port group qspim0 to this pad." }
                      { value: "18", name: "port_qspim0_sdio3", desc: "Connect port sdio3 from port group qspim0 to this pad." }
                      { value: "19", name: "port_qspis0_csn", desc: "Connect port csn from port group qspis0 to this pad." }
                      { value: "20", name: "port_qspis0_sck", desc: "Connect port sck from port group qspis0 to this pad." }
                      { value: "21", name: "port_qspis0_sdio0", desc: "Connect port sdio0 from port group qspis0 to this pad." }
                      { value: "22", name: "port_qspis0_sdio1", desc: "Connect port sdio1 from port group qspis0 to this pad." }
                      { value: "23", name: "port_qspis0_sdio2", desc: "Connect port sdio2 from port group qspis0 to this pad." }
                      { value: "24", name: "port_qspis0_sdio3", desc: "Connect port sdio3 from port group qspis0 to this pad." }
                      { value: "25", name: "port_uart0_rx", desc: "Connect port rx from port group uart0 to this pad." }
                      { value: "26", name: "port_uart0_tx", desc: "Connect port tx from port group uart0 to this pad." }
                  ]
              }
          ]
      }

    ]
}

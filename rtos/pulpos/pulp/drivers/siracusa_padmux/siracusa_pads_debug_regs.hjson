
{
    # File auto-generated by Padrick unknown
    name: "siracusa_pads_debug_config"
    clock_primary: "clk_i"
    reset_primary: "rst_ni"
    bus_interfaces: [
        { protocol: "reg_iface", direction: "device"}
    ]
    regwidth: 32,
    registers: [
        {skipto: "0x158"},
      {
          name: PAD_GPIO00_CFG
          desc: '''
            Pad signal configuration.
          '''
          swaccess: "rw"
          fields: [
            {
                bits: "0"
                name: chip2pad
                desc: '''
                     Connects to pad's TX driver
                '''
                swaccess: "rw"
                hwaccess: "hro"
                resval: "0"
            },
            {
                bits: "1"
                name: drv0
                desc: '''
                     Choose the driving strength of the pad. LSB = ~3mA
                '''
                swaccess: "rw"
                hwaccess: "hro"
                resval: "0"
            },
            {
                bits: "2"
                name: drv1
                desc: '''
                     Choose the driving strength of the pad. LSB = ~3mA
                '''
                swaccess: "rw"
                hwaccess: "hro"
                resval: "0"
            },
            {
                bits: "3"
                name: drv2
                desc: '''
                     Choose the driving strength of the pad. LSB = ~3mA
                '''
                swaccess: "rw"
                hwaccess: "hro"
                resval: "0"
            },
            {
                bits: "4"
                name: drv3
                desc: '''
                     Choose the driving strength of the pad. LSB = ~3mA
                '''
                swaccess: "rw"
                hwaccess: "hro"
                resval: "1"
            },
            {
                bits: "5"
                name: pull_en
                desc: '''
                     Enable pull up/down (depends on pull_sel) resistor, active-high
                '''
                swaccess: "rw"
                hwaccess: "hro"
                resval: "0"
            },
            {
                bits: "6"
                name: pull_sel
                desc: '''
                     1 -> use pull-up resistor (if pull_en == 1), 0 -> use pull-down resistor
                '''
                swaccess: "rw"
                hwaccess: "hro"
                resval: "0"
            },
            {
                bits: "7"
                name: ret_en
                desc: '''
                     Enable retention mode, active-high
                '''
                swaccess: "rw"
                hwaccess: "hro"
                resval: "0"
            },
            {
                bits: "8"
                name: st_en
                desc: '''
                     Schmitt-trigger enable, active high
                '''
                swaccess: "rw"
                hwaccess: "hro"
                resval: "0"
            },
            {
                bits: "9"
                name: tx_en
                desc: '''
                     TX driver enable, active low
                '''
                swaccess: "rw"
                hwaccess: "hro"
                resval: "0"
            },
          ]
      }

       {
          name: PAD_GPIO00_MUX_SEL
          desc: '''
              Pad signal port multiplex selection for pad pad_gpio00. The programmed value defines which port
              is connected to the pad.
          '''
          swaccess: "rw"
          hwaccess: "hro"
          resval: 1
          fields: [
              {
                  bits: "3:0"
                  enum: [
                      { value: "0", name: "register", desc: "Connects the Pad to the internal configuration register."}
                      { value: "1", name: "port_mram_debug_bank0_bist_run", desc: "Connect port bank0_bist_run from port group mram_debug to this pad." }
                      { value: "2", name: "port_mram_debug_bank1_bist_run", desc: "Connect port bank1_bist_run from port group mram_debug to this pad." }
                      { value: "3", name: "port_mram_debug_bank2_bist_run", desc: "Connect port bank2_bist_run from port group mram_debug to this pad." }
                      { value: "4", name: "port_mram_debug_bank3_bist_run", desc: "Connect port bank3_bist_run from port group mram_debug to this pad." }
                      { value: "5", name: "port_mram_debug_bank4_bist_run", desc: "Connect port bank4_bist_run from port group mram_debug to this pad." }
                      { value: "6", name: "port_mram_debug_bank5_bist_run", desc: "Connect port bank5_bist_run from port group mram_debug to this pad." }
                      { value: "7", name: "port_mram_debug_bank6_bist_run", desc: "Connect port bank6_bist_run from port group mram_debug to this pad." }
                      { value: "8", name: "port_mram_debug_bank7_bist_run", desc: "Connect port bank7_bist_run from port group mram_debug to this pad." }
                      { value: "9", name: "port_observables_s_cluster_rstn", desc: "Connect port s_cluster_rstn from port group observables to this pad." }
                      { value: "10", name: "port_observables_s_soc_rstn", desc: "Connect port s_soc_rstn from port group observables to this pad." }
                  ]
              }
          ]
      }

      {
          name: PAD_GPIO01_CFG
          desc: '''
            Pad signal configuration.
          '''
          swaccess: "rw"
          fields: [
            {
                bits: "0"
                name: chip2pad
                desc: '''
                     Connects to pad's TX driver
                '''
                swaccess: "rw"
                hwaccess: "hro"
                resval: "0"
            },
            {
                bits: "1"
                name: drv0
                desc: '''
                     Choose the driving strength of the pad. LSB = ~3mA
                '''
                swaccess: "rw"
                hwaccess: "hro"
                resval: "0"
            },
            {
                bits: "2"
                name: drv1
                desc: '''
                     Choose the driving strength of the pad. LSB = ~3mA
                '''
                swaccess: "rw"
                hwaccess: "hro"
                resval: "0"
            },
            {
                bits: "3"
                name: drv2
                desc: '''
                     Choose the driving strength of the pad. LSB = ~3mA
                '''
                swaccess: "rw"
                hwaccess: "hro"
                resval: "0"
            },
            {
                bits: "4"
                name: drv3
                desc: '''
                     Choose the driving strength of the pad. LSB = ~3mA
                '''
                swaccess: "rw"
                hwaccess: "hro"
                resval: "1"
            },
            {
                bits: "5"
                name: pull_en
                desc: '''
                     Enable pull up/down (depends on pull_sel) resistor, active-high
                '''
                swaccess: "rw"
                hwaccess: "hro"
                resval: "0"
            },
            {
                bits: "6"
                name: pull_sel
                desc: '''
                     1 -> use pull-up resistor (if pull_en == 1), 0 -> use pull-down resistor
                '''
                swaccess: "rw"
                hwaccess: "hro"
                resval: "0"
            },
            {
                bits: "7"
                name: ret_en
                desc: '''
                     Enable retention mode, active-high
                '''
                swaccess: "rw"
                hwaccess: "hro"
                resval: "0"
            },
            {
                bits: "8"
                name: st_en
                desc: '''
                     Schmitt-trigger enable, active high
                '''
                swaccess: "rw"
                hwaccess: "hro"
                resval: "0"
            },
            {
                bits: "9"
                name: tx_en
                desc: '''
                     TX driver enable, active low
                '''
                swaccess: "rw"
                hwaccess: "hro"
                resval: "0"
            },
          ]
      }

       {
          name: PAD_GPIO01_MUX_SEL
          desc: '''
              Pad signal port multiplex selection for pad pad_gpio01. The programmed value defines which port
              is connected to the pad.
          '''
          swaccess: "rw"
          hwaccess: "hro"
          resval: 1
          fields: [
              {
                  bits: "3:0"
                  enum: [
                      { value: "0", name: "register", desc: "Connects the Pad to the internal configuration register."}
                      { value: "1", name: "port_mram_debug_bank0_bist_done", desc: "Connect port bank0_bist_done from port group mram_debug to this pad." }
                      { value: "2", name: "port_mram_debug_bank1_bist_done", desc: "Connect port bank1_bist_done from port group mram_debug to this pad." }
                      { value: "3", name: "port_mram_debug_bank2_bist_done", desc: "Connect port bank2_bist_done from port group mram_debug to this pad." }
                      { value: "4", name: "port_mram_debug_bank3_bist_done", desc: "Connect port bank3_bist_done from port group mram_debug to this pad." }
                      { value: "5", name: "port_mram_debug_bank4_bist_done", desc: "Connect port bank4_bist_done from port group mram_debug to this pad." }
                      { value: "6", name: "port_mram_debug_bank5_bist_done", desc: "Connect port bank5_bist_done from port group mram_debug to this pad." }
                      { value: "7", name: "port_mram_debug_bank6_bist_done", desc: "Connect port bank6_bist_done from port group mram_debug to this pad." }
                      { value: "8", name: "port_mram_debug_bank7_bist_done", desc: "Connect port bank7_bist_done from port group mram_debug to this pad." }
                      { value: "9", name: "port_observables_s_cluster_rstn", desc: "Connect port s_cluster_rstn from port group observables to this pad." }
                      { value: "10", name: "port_observables_s_soc_rstn", desc: "Connect port s_soc_rstn from port group observables to this pad." }
                  ]
              }
          ]
      }

      {
          name: PAD_GPIO02_CFG
          desc: '''
            Pad signal configuration.
          '''
          swaccess: "rw"
          fields: [
            {
                bits: "0"
                name: chip2pad
                desc: '''
                     Connects to pad's TX driver
                '''
                swaccess: "rw"
                hwaccess: "hro"
                resval: "0"
            },
            {
                bits: "1"
                name: drv0
                desc: '''
                     Choose the driving strength of the pad. LSB = ~3mA
                '''
                swaccess: "rw"
                hwaccess: "hro"
                resval: "0"
            },
            {
                bits: "2"
                name: drv1
                desc: '''
                     Choose the driving strength of the pad. LSB = ~3mA
                '''
                swaccess: "rw"
                hwaccess: "hro"
                resval: "0"
            },
            {
                bits: "3"
                name: drv2
                desc: '''
                     Choose the driving strength of the pad. LSB = ~3mA
                '''
                swaccess: "rw"
                hwaccess: "hro"
                resval: "0"
            },
            {
                bits: "4"
                name: drv3
                desc: '''
                     Choose the driving strength of the pad. LSB = ~3mA
                '''
                swaccess: "rw"
                hwaccess: "hro"
                resval: "1"
            },
            {
                bits: "5"
                name: pull_en
                desc: '''
                     Enable pull up/down (depends on pull_sel) resistor, active-high
                '''
                swaccess: "rw"
                hwaccess: "hro"
                resval: "0"
            },
            {
                bits: "6"
                name: pull_sel
                desc: '''
                     1 -> use pull-up resistor (if pull_en == 1), 0 -> use pull-down resistor
                '''
                swaccess: "rw"
                hwaccess: "hro"
                resval: "0"
            },
            {
                bits: "7"
                name: ret_en
                desc: '''
                     Enable retention mode, active-high
                '''
                swaccess: "rw"
                hwaccess: "hro"
                resval: "0"
            },
            {
                bits: "8"
                name: st_en
                desc: '''
                     Schmitt-trigger enable, active high
                '''
                swaccess: "rw"
                hwaccess: "hro"
                resval: "0"
            },
            {
                bits: "9"
                name: tx_en
                desc: '''
                     TX driver enable, active low
                '''
                swaccess: "rw"
                hwaccess: "hro"
                resval: "0"
            },
          ]
      }

       {
          name: PAD_GPIO02_MUX_SEL
          desc: '''
              Pad signal port multiplex selection for pad pad_gpio02. The programmed value defines which port
              is connected to the pad.
          '''
          swaccess: "rw"
          hwaccess: "hro"
          resval: 1
          fields: [
              {
                  bits: "3:0"
                  enum: [
                      { value: "0", name: "register", desc: "Connects the Pad to the internal configuration register."}
                      { value: "1", name: "port_mram_debug_bank0_bist_fail", desc: "Connect port bank0_bist_fail from port group mram_debug to this pad." }
                      { value: "2", name: "port_mram_debug_bank1_bist_fail", desc: "Connect port bank1_bist_fail from port group mram_debug to this pad." }
                      { value: "3", name: "port_mram_debug_bank2_bist_fail", desc: "Connect port bank2_bist_fail from port group mram_debug to this pad." }
                      { value: "4", name: "port_mram_debug_bank3_bist_fail", desc: "Connect port bank3_bist_fail from port group mram_debug to this pad." }
                      { value: "5", name: "port_mram_debug_bank4_bist_fail", desc: "Connect port bank4_bist_fail from port group mram_debug to this pad." }
                      { value: "6", name: "port_mram_debug_bank5_bist_fail", desc: "Connect port bank5_bist_fail from port group mram_debug to this pad." }
                      { value: "7", name: "port_mram_debug_bank6_bist_fail", desc: "Connect port bank6_bist_fail from port group mram_debug to this pad." }
                      { value: "8", name: "port_mram_debug_bank7_bist_fail", desc: "Connect port bank7_bist_fail from port group mram_debug to this pad." }
                      { value: "9", name: "port_observables_s_cluster_rstn", desc: "Connect port s_cluster_rstn from port group observables to this pad." }
                      { value: "10", name: "port_observables_s_soc_rstn", desc: "Connect port s_soc_rstn from port group observables to this pad." }
                  ]
              }
          ]
      }

      {
          name: PAD_GPIO03_CFG
          desc: '''
            Pad signal configuration.
          '''
          swaccess: "rw"
          fields: [
            {
                bits: "0"
                name: chip2pad
                desc: '''
                     Connects to pad's TX driver
                '''
                swaccess: "rw"
                hwaccess: "hro"
                resval: "0"
            },
            {
                bits: "1"
                name: drv0
                desc: '''
                     Choose the driving strength of the pad. LSB = ~3mA
                '''
                swaccess: "rw"
                hwaccess: "hro"
                resval: "0"
            },
            {
                bits: "2"
                name: drv1
                desc: '''
                     Choose the driving strength of the pad. LSB = ~3mA
                '''
                swaccess: "rw"
                hwaccess: "hro"
                resval: "0"
            },
            {
                bits: "3"
                name: drv2
                desc: '''
                     Choose the driving strength of the pad. LSB = ~3mA
                '''
                swaccess: "rw"
                hwaccess: "hro"
                resval: "0"
            },
            {
                bits: "4"
                name: drv3
                desc: '''
                     Choose the driving strength of the pad. LSB = ~3mA
                '''
                swaccess: "rw"
                hwaccess: "hro"
                resval: "1"
            },
            {
                bits: "5"
                name: pull_en
                desc: '''
                     Enable pull up/down (depends on pull_sel) resistor, active-high
                '''
                swaccess: "rw"
                hwaccess: "hro"
                resval: "0"
            },
            {
                bits: "6"
                name: pull_sel
                desc: '''
                     1 -> use pull-up resistor (if pull_en == 1), 0 -> use pull-down resistor
                '''
                swaccess: "rw"
                hwaccess: "hro"
                resval: "0"
            },
            {
                bits: "7"
                name: ret_en
                desc: '''
                     Enable retention mode, active-high
                '''
                swaccess: "rw"
                hwaccess: "hro"
                resval: "0"
            },
            {
                bits: "8"
                name: st_en
                desc: '''
                     Schmitt-trigger enable, active high
                '''
                swaccess: "rw"
                hwaccess: "hro"
                resval: "0"
            },
            {
                bits: "9"
                name: tx_en
                desc: '''
                     TX driver enable, active low
                '''
                swaccess: "rw"
                hwaccess: "hro"
                resval: "0"
            },
          ]
      }

       {
          name: PAD_GPIO03_MUX_SEL
          desc: '''
              Pad signal port multiplex selection for pad pad_gpio03. The programmed value defines which port
              is connected to the pad.
          '''
          swaccess: "rw"
          hwaccess: "hro"
          resval: 1
          fields: [
              {
                  bits: "1:0"
                  enum: [
                      { value: "0", name: "register", desc: "Connects the Pad to the internal configuration register."}
                      { value: "1", name: "port_mram_debug_mdc", desc: "Connect port mdc from port group mram_debug to this pad." }
                      { value: "2", name: "port_observables_s_cluster_rstn", desc: "Connect port s_cluster_rstn from port group observables to this pad." }
                      { value: "3", name: "port_observables_s_soc_rstn", desc: "Connect port s_soc_rstn from port group observables to this pad." }
                  ]
              }
          ]
      }

      {
          name: PAD_GPIO04_CFG
          desc: '''
            Pad signal configuration.
          '''
          swaccess: "rw"
          fields: [
            {
                bits: "0"
                name: chip2pad
                desc: '''
                     Connects to pad's TX driver
                '''
                swaccess: "rw"
                hwaccess: "hro"
                resval: "0"
            },
            {
                bits: "1"
                name: drv0
                desc: '''
                     Choose the driving strength of the pad. LSB = ~3mA
                '''
                swaccess: "rw"
                hwaccess: "hro"
                resval: "0"
            },
            {
                bits: "2"
                name: drv1
                desc: '''
                     Choose the driving strength of the pad. LSB = ~3mA
                '''
                swaccess: "rw"
                hwaccess: "hro"
                resval: "0"
            },
            {
                bits: "3"
                name: drv2
                desc: '''
                     Choose the driving strength of the pad. LSB = ~3mA
                '''
                swaccess: "rw"
                hwaccess: "hro"
                resval: "0"
            },
            {
                bits: "4"
                name: drv3
                desc: '''
                     Choose the driving strength of the pad. LSB = ~3mA
                '''
                swaccess: "rw"
                hwaccess: "hro"
                resval: "1"
            },
            {
                bits: "5"
                name: pull_en
                desc: '''
                     Enable pull up/down (depends on pull_sel) resistor, active-high
                '''
                swaccess: "rw"
                hwaccess: "hro"
                resval: "0"
            },
            {
                bits: "6"
                name: pull_sel
                desc: '''
                     1 -> use pull-up resistor (if pull_en == 1), 0 -> use pull-down resistor
                '''
                swaccess: "rw"
                hwaccess: "hro"
                resval: "0"
            },
            {
                bits: "7"
                name: ret_en
                desc: '''
                     Enable retention mode, active-high
                '''
                swaccess: "rw"
                hwaccess: "hro"
                resval: "0"
            },
            {
                bits: "8"
                name: st_en
                desc: '''
                     Schmitt-trigger enable, active high
                '''
                swaccess: "rw"
                hwaccess: "hro"
                resval: "0"
            },
            {
                bits: "9"
                name: tx_en
                desc: '''
                     TX driver enable, active low
                '''
                swaccess: "rw"
                hwaccess: "hro"
                resval: "0"
            },
          ]
      }

       {
          name: PAD_GPIO04_MUX_SEL
          desc: '''
              Pad signal port multiplex selection for pad pad_gpio04. The programmed value defines which port
              is connected to the pad.
          '''
          swaccess: "rw"
          hwaccess: "hro"
          resval: 1
          fields: [
              {
                  bits: "1:0"
                  enum: [
                      { value: "0", name: "register", desc: "Connects the Pad to the internal configuration register."}
                      { value: "1", name: "port_mram_debug_mdin", desc: "Connect port mdin from port group mram_debug to this pad." }
                      { value: "2", name: "port_observables_s_cluster_rstn", desc: "Connect port s_cluster_rstn from port group observables to this pad." }
                      { value: "3", name: "port_observables_s_soc_rstn", desc: "Connect port s_soc_rstn from port group observables to this pad." }
                  ]
              }
          ]
      }

      {
          name: PAD_GPIO05_CFG
          desc: '''
            Pad signal configuration.
          '''
          swaccess: "rw"
          fields: [
            {
                bits: "0"
                name: chip2pad
                desc: '''
                     Connects to pad's TX driver
                '''
                swaccess: "rw"
                hwaccess: "hro"
                resval: "0"
            },
            {
                bits: "1"
                name: drv0
                desc: '''
                     Choose the driving strength of the pad. LSB = ~3mA
                '''
                swaccess: "rw"
                hwaccess: "hro"
                resval: "0"
            },
            {
                bits: "2"
                name: drv1
                desc: '''
                     Choose the driving strength of the pad. LSB = ~3mA
                '''
                swaccess: "rw"
                hwaccess: "hro"
                resval: "0"
            },
            {
                bits: "3"
                name: drv2
                desc: '''
                     Choose the driving strength of the pad. LSB = ~3mA
                '''
                swaccess: "rw"
                hwaccess: "hro"
                resval: "0"
            },
            {
                bits: "4"
                name: drv3
                desc: '''
                     Choose the driving strength of the pad. LSB = ~3mA
                '''
                swaccess: "rw"
                hwaccess: "hro"
                resval: "1"
            },
            {
                bits: "5"
                name: pull_en
                desc: '''
                     Enable pull up/down (depends on pull_sel) resistor, active-high
                '''
                swaccess: "rw"
                hwaccess: "hro"
                resval: "0"
            },
            {
                bits: "6"
                name: pull_sel
                desc: '''
                     1 -> use pull-up resistor (if pull_en == 1), 0 -> use pull-down resistor
                '''
                swaccess: "rw"
                hwaccess: "hro"
                resval: "0"
            },
            {
                bits: "7"
                name: ret_en
                desc: '''
                     Enable retention mode, active-high
                '''
                swaccess: "rw"
                hwaccess: "hro"
                resval: "0"
            },
            {
                bits: "8"
                name: st_en
                desc: '''
                     Schmitt-trigger enable, active high
                '''
                swaccess: "rw"
                hwaccess: "hro"
                resval: "0"
            },
            {
                bits: "9"
                name: tx_en
                desc: '''
                     TX driver enable, active low
                '''
                swaccess: "rw"
                hwaccess: "hro"
                resval: "0"
            },
          ]
      }

       {
          name: PAD_GPIO05_MUX_SEL
          desc: '''
              Pad signal port multiplex selection for pad pad_gpio05. The programmed value defines which port
              is connected to the pad.
          '''
          swaccess: "rw"
          hwaccess: "hro"
          resval: 1
          fields: [
              {
                  bits: "1:0"
                  enum: [
                      { value: "0", name: "register", desc: "Connects the Pad to the internal configuration register."}
                      { value: "1", name: "port_mram_debug_mdout", desc: "Connect port mdout from port group mram_debug to this pad." }
                      { value: "2", name: "port_observables_s_cluster_rstn", desc: "Connect port s_cluster_rstn from port group observables to this pad." }
                      { value: "3", name: "port_observables_s_soc_rstn", desc: "Connect port s_soc_rstn from port group observables to this pad." }
                  ]
              }
          ]
      }

      {
          name: PAD_GPIO06_CFG
          desc: '''
            Pad signal configuration.
          '''
          swaccess: "rw"
          fields: [
            {
                bits: "0"
                name: chip2pad
                desc: '''
                     Connects to pad's TX driver
                '''
                swaccess: "rw"
                hwaccess: "hro"
                resval: "0"
            },
            {
                bits: "1"
                name: drv0
                desc: '''
                     Choose the driving strength of the pad. LSB = ~3mA
                '''
                swaccess: "rw"
                hwaccess: "hro"
                resval: "0"
            },
            {
                bits: "2"
                name: drv1
                desc: '''
                     Choose the driving strength of the pad. LSB = ~3mA
                '''
                swaccess: "rw"
                hwaccess: "hro"
                resval: "0"
            },
            {
                bits: "3"
                name: drv2
                desc: '''
                     Choose the driving strength of the pad. LSB = ~3mA
                '''
                swaccess: "rw"
                hwaccess: "hro"
                resval: "0"
            },
            {
                bits: "4"
                name: drv3
                desc: '''
                     Choose the driving strength of the pad. LSB = ~3mA
                '''
                swaccess: "rw"
                hwaccess: "hro"
                resval: "1"
            },
            {
                bits: "5"
                name: pull_en
                desc: '''
                     Enable pull up/down (depends on pull_sel) resistor, active-high
                '''
                swaccess: "rw"
                hwaccess: "hro"
                resval: "0"
            },
            {
                bits: "6"
                name: pull_sel
                desc: '''
                     1 -> use pull-up resistor (if pull_en == 1), 0 -> use pull-down resistor
                '''
                swaccess: "rw"
                hwaccess: "hro"
                resval: "0"
            },
            {
                bits: "7"
                name: ret_en
                desc: '''
                     Enable retention mode, active-high
                '''
                swaccess: "rw"
                hwaccess: "hro"
                resval: "0"
            },
            {
                bits: "8"
                name: st_en
                desc: '''
                     Schmitt-trigger enable, active high
                '''
                swaccess: "rw"
                hwaccess: "hro"
                resval: "0"
            },
            {
                bits: "9"
                name: tx_en
                desc: '''
                     TX driver enable, active low
                '''
                swaccess: "rw"
                hwaccess: "hro"
                resval: "0"
            },
          ]
      }

       {
          name: PAD_GPIO06_MUX_SEL
          desc: '''
              Pad signal port multiplex selection for pad pad_gpio06. The programmed value defines which port
              is connected to the pad.
          '''
          swaccess: "rw"
          hwaccess: "hro"
          resval: 1
          fields: [
              {
                  bits: "3:0"
                  enum: [
                      { value: "0", name: "register", desc: "Connects the Pad to the internal configuration register."}
                      { value: "1", name: "port_mram_debug_bank0_se", desc: "Connect port bank0_se from port group mram_debug to this pad." }
                      { value: "2", name: "port_mram_debug_bank1_se", desc: "Connect port bank1_se from port group mram_debug to this pad." }
                      { value: "3", name: "port_mram_debug_bank2_se", desc: "Connect port bank2_se from port group mram_debug to this pad." }
                      { value: "4", name: "port_mram_debug_bank3_se", desc: "Connect port bank3_se from port group mram_debug to this pad." }
                      { value: "5", name: "port_mram_debug_bank4_se", desc: "Connect port bank4_se from port group mram_debug to this pad." }
                      { value: "6", name: "port_mram_debug_bank5_se", desc: "Connect port bank5_se from port group mram_debug to this pad." }
                      { value: "7", name: "port_mram_debug_bank6_se", desc: "Connect port bank6_se from port group mram_debug to this pad." }
                      { value: "8", name: "port_mram_debug_bank7_se", desc: "Connect port bank7_se from port group mram_debug to this pad." }
                      { value: "9", name: "port_observables_s_cluster_rstn", desc: "Connect port s_cluster_rstn from port group observables to this pad." }
                      { value: "10", name: "port_observables_s_soc_rstn", desc: "Connect port s_soc_rstn from port group observables to this pad." }
                  ]
              }
          ]
      }

      {
          name: PAD_GPIO07_CFG
          desc: '''
            Pad signal configuration.
          '''
          swaccess: "rw"
          fields: [
            {
                bits: "0"
                name: chip2pad
                desc: '''
                     Connects to pad's TX driver
                '''
                swaccess: "rw"
                hwaccess: "hro"
                resval: "0"
            },
            {
                bits: "1"
                name: drv0
                desc: '''
                     Choose the driving strength of the pad. LSB = ~3mA
                '''
                swaccess: "rw"
                hwaccess: "hro"
                resval: "0"
            },
            {
                bits: "2"
                name: drv1
                desc: '''
                     Choose the driving strength of the pad. LSB = ~3mA
                '''
                swaccess: "rw"
                hwaccess: "hro"
                resval: "0"
            },
            {
                bits: "3"
                name: drv2
                desc: '''
                     Choose the driving strength of the pad. LSB = ~3mA
                '''
                swaccess: "rw"
                hwaccess: "hro"
                resval: "0"
            },
            {
                bits: "4"
                name: drv3
                desc: '''
                     Choose the driving strength of the pad. LSB = ~3mA
                '''
                swaccess: "rw"
                hwaccess: "hro"
                resval: "1"
            },
            {
                bits: "5"
                name: pull_en
                desc: '''
                     Enable pull up/down (depends on pull_sel) resistor, active-high
                '''
                swaccess: "rw"
                hwaccess: "hro"
                resval: "0"
            },
            {
                bits: "6"
                name: pull_sel
                desc: '''
                     1 -> use pull-up resistor (if pull_en == 1), 0 -> use pull-down resistor
                '''
                swaccess: "rw"
                hwaccess: "hro"
                resval: "0"
            },
            {
                bits: "7"
                name: ret_en
                desc: '''
                     Enable retention mode, active-high
                '''
                swaccess: "rw"
                hwaccess: "hro"
                resval: "0"
            },
            {
                bits: "8"
                name: st_en
                desc: '''
                     Schmitt-trigger enable, active high
                '''
                swaccess: "rw"
                hwaccess: "hro"
                resval: "0"
            },
            {
                bits: "9"
                name: tx_en
                desc: '''
                     TX driver enable, active low
                '''
                swaccess: "rw"
                hwaccess: "hro"
                resval: "0"
            },
          ]
      }

       {
          name: PAD_GPIO07_MUX_SEL
          desc: '''
              Pad signal port multiplex selection for pad pad_gpio07. The programmed value defines which port
              is connected to the pad.
          '''
          swaccess: "rw"
          hwaccess: "hro"
          resval: 1
          fields: [
              {
                  bits: "3:0"
                  enum: [
                      { value: "0", name: "register", desc: "Connects the Pad to the internal configuration register."}
                      { value: "1", name: "port_mram_debug_bank0_si", desc: "Connect port bank0_si from port group mram_debug to this pad." }
                      { value: "2", name: "port_mram_debug_bank1_si", desc: "Connect port bank1_si from port group mram_debug to this pad." }
                      { value: "3", name: "port_mram_debug_bank2_si", desc: "Connect port bank2_si from port group mram_debug to this pad." }
                      { value: "4", name: "port_mram_debug_bank3_si", desc: "Connect port bank3_si from port group mram_debug to this pad." }
                      { value: "5", name: "port_mram_debug_bank4_si", desc: "Connect port bank4_si from port group mram_debug to this pad." }
                      { value: "6", name: "port_mram_debug_bank5_si", desc: "Connect port bank5_si from port group mram_debug to this pad." }
                      { value: "7", name: "port_mram_debug_bank6_si", desc: "Connect port bank6_si from port group mram_debug to this pad." }
                      { value: "8", name: "port_mram_debug_bank7_si", desc: "Connect port bank7_si from port group mram_debug to this pad." }
                      { value: "9", name: "port_observables_s_cluster_rstn", desc: "Connect port s_cluster_rstn from port group observables to this pad." }
                      { value: "10", name: "port_observables_s_soc_rstn", desc: "Connect port s_soc_rstn from port group observables to this pad." }
                  ]
              }
          ]
      }

      {
          name: PAD_GPIO08_CFG
          desc: '''
            Pad signal configuration.
          '''
          swaccess: "rw"
          fields: [
            {
                bits: "0"
                name: chip2pad
                desc: '''
                     Connects to pad's TX driver
                '''
                swaccess: "rw"
                hwaccess: "hro"
                resval: "0"
            },
            {
                bits: "1"
                name: drv0
                desc: '''
                     Choose the driving strength of the pad. LSB = ~3mA
                '''
                swaccess: "rw"
                hwaccess: "hro"
                resval: "0"
            },
            {
                bits: "2"
                name: drv1
                desc: '''
                     Choose the driving strength of the pad. LSB = ~3mA
                '''
                swaccess: "rw"
                hwaccess: "hro"
                resval: "0"
            },
            {
                bits: "3"
                name: drv2
                desc: '''
                     Choose the driving strength of the pad. LSB = ~3mA
                '''
                swaccess: "rw"
                hwaccess: "hro"
                resval: "0"
            },
            {
                bits: "4"
                name: drv3
                desc: '''
                     Choose the driving strength of the pad. LSB = ~3mA
                '''
                swaccess: "rw"
                hwaccess: "hro"
                resval: "1"
            },
            {
                bits: "5"
                name: pull_en
                desc: '''
                     Enable pull up/down (depends on pull_sel) resistor, active-high
                '''
                swaccess: "rw"
                hwaccess: "hro"
                resval: "0"
            },
            {
                bits: "6"
                name: pull_sel
                desc: '''
                     1 -> use pull-up resistor (if pull_en == 1), 0 -> use pull-down resistor
                '''
                swaccess: "rw"
                hwaccess: "hro"
                resval: "0"
            },
            {
                bits: "7"
                name: ret_en
                desc: '''
                     Enable retention mode, active-high
                '''
                swaccess: "rw"
                hwaccess: "hro"
                resval: "0"
            },
            {
                bits: "8"
                name: st_en
                desc: '''
                     Schmitt-trigger enable, active high
                '''
                swaccess: "rw"
                hwaccess: "hro"
                resval: "0"
            },
            {
                bits: "9"
                name: tx_en
                desc: '''
                     TX driver enable, active low
                '''
                swaccess: "rw"
                hwaccess: "hro"
                resval: "0"
            },
          ]
      }

       {
          name: PAD_GPIO08_MUX_SEL
          desc: '''
              Pad signal port multiplex selection for pad pad_gpio08. The programmed value defines which port
              is connected to the pad.
          '''
          swaccess: "rw"
          hwaccess: "hro"
          resval: 1
          fields: [
              {
                  bits: "3:0"
                  enum: [
                      { value: "0", name: "register", desc: "Connects the Pad to the internal configuration register."}
                      { value: "1", name: "port_mram_debug_bank0_so", desc: "Connect port bank0_so from port group mram_debug to this pad." }
                      { value: "2", name: "port_mram_debug_bank1_so", desc: "Connect port bank1_so from port group mram_debug to this pad." }
                      { value: "3", name: "port_mram_debug_bank2_so", desc: "Connect port bank2_so from port group mram_debug to this pad." }
                      { value: "4", name: "port_mram_debug_bank3_so", desc: "Connect port bank3_so from port group mram_debug to this pad." }
                      { value: "5", name: "port_mram_debug_bank4_so", desc: "Connect port bank4_so from port group mram_debug to this pad." }
                      { value: "6", name: "port_mram_debug_bank5_so", desc: "Connect port bank5_so from port group mram_debug to this pad." }
                      { value: "7", name: "port_mram_debug_bank6_so", desc: "Connect port bank6_so from port group mram_debug to this pad." }
                      { value: "8", name: "port_mram_debug_bank7_so", desc: "Connect port bank7_so from port group mram_debug to this pad." }
                      { value: "9", name: "port_observables_s_cluster_rstn", desc: "Connect port s_cluster_rstn from port group observables to this pad." }
                      { value: "10", name: "port_observables_s_soc_rstn", desc: "Connect port s_soc_rstn from port group observables to this pad." }
                  ]
              }
          ]
      }

      {
          name: PAD_GPIO09_CFG
          desc: '''
            Pad signal configuration.
          '''
          swaccess: "rw"
          fields: [
            {
                bits: "0"
                name: chip2pad
                desc: '''
                     Connects to pad's TX driver
                '''
                swaccess: "rw"
                hwaccess: "hro"
                resval: "0"
            },
            {
                bits: "1"
                name: drv0
                desc: '''
                     Choose the driving strength of the pad. LSB = ~3mA
                '''
                swaccess: "rw"
                hwaccess: "hro"
                resval: "0"
            },
            {
                bits: "2"
                name: drv1
                desc: '''
                     Choose the driving strength of the pad. LSB = ~3mA
                '''
                swaccess: "rw"
                hwaccess: "hro"
                resval: "0"
            },
            {
                bits: "3"
                name: drv2
                desc: '''
                     Choose the driving strength of the pad. LSB = ~3mA
                '''
                swaccess: "rw"
                hwaccess: "hro"
                resval: "0"
            },
            {
                bits: "4"
                name: drv3
                desc: '''
                     Choose the driving strength of the pad. LSB = ~3mA
                '''
                swaccess: "rw"
                hwaccess: "hro"
                resval: "1"
            },
            {
                bits: "5"
                name: pull_en
                desc: '''
                     Enable pull up/down (depends on pull_sel) resistor, active-high
                '''
                swaccess: "rw"
                hwaccess: "hro"
                resval: "0"
            },
            {
                bits: "6"
                name: pull_sel
                desc: '''
                     1 -> use pull-up resistor (if pull_en == 1), 0 -> use pull-down resistor
                '''
                swaccess: "rw"
                hwaccess: "hro"
                resval: "0"
            },
            {
                bits: "7"
                name: ret_en
                desc: '''
                     Enable retention mode, active-high
                '''
                swaccess: "rw"
                hwaccess: "hro"
                resval: "0"
            },
            {
                bits: "8"
                name: st_en
                desc: '''
                     Schmitt-trigger enable, active high
                '''
                swaccess: "rw"
                hwaccess: "hro"
                resval: "0"
            },
            {
                bits: "9"
                name: tx_en
                desc: '''
                     TX driver enable, active low
                '''
                swaccess: "rw"
                hwaccess: "hro"
                resval: "0"
            },
          ]
      }

       {
          name: PAD_GPIO09_MUX_SEL
          desc: '''
              Pad signal port multiplex selection for pad pad_gpio09. The programmed value defines which port
              is connected to the pad.
          '''
          swaccess: "rw"
          hwaccess: "hro"
          resval: 1
          fields: [
              {
                  bits: "3:0"
                  enum: [
                      { value: "0", name: "register", desc: "Connects the Pad to the internal configuration register."}
                      { value: "1", name: "port_mram_debug_tm_signals_bank0_tm2", desc: "Connect port bank0_tm2 from port group mram_debug_tm_signals to this pad." }
                      { value: "2", name: "port_mram_debug_tm_signals_bank1_tm2", desc: "Connect port bank1_tm2 from port group mram_debug_tm_signals to this pad." }
                      { value: "3", name: "port_mram_debug_tm_signals_bank2_tm2", desc: "Connect port bank2_tm2 from port group mram_debug_tm_signals to this pad." }
                      { value: "4", name: "port_mram_debug_tm_signals_bank3_tm2", desc: "Connect port bank3_tm2 from port group mram_debug_tm_signals to this pad." }
                      { value: "5", name: "port_mram_debug_tm_signals_bank4_tm2", desc: "Connect port bank4_tm2 from port group mram_debug_tm_signals to this pad." }
                      { value: "6", name: "port_mram_debug_tm_signals_bank5_tm2", desc: "Connect port bank5_tm2 from port group mram_debug_tm_signals to this pad." }
                      { value: "7", name: "port_mram_debug_tm_signals_bank6_tm2", desc: "Connect port bank6_tm2 from port group mram_debug_tm_signals to this pad." }
                      { value: "8", name: "port_mram_debug_tm_signals_bank7_tm2", desc: "Connect port bank7_tm2 from port group mram_debug_tm_signals to this pad." }
                      { value: "9", name: "port_observables_s_cluster_rstn", desc: "Connect port s_cluster_rstn from port group observables to this pad." }
                      { value: "10", name: "port_observables_s_soc_rstn", desc: "Connect port s_soc_rstn from port group observables to this pad." }
                  ]
              }
          ]
      }

      {
          name: PAD_GPIO10_CFG
          desc: '''
            Pad signal configuration.
          '''
          swaccess: "rw"
          fields: [
            {
                bits: "0"
                name: chip2pad
                desc: '''
                     Connects to pad's TX driver
                '''
                swaccess: "rw"
                hwaccess: "hro"
                resval: "0"
            },
            {
                bits: "1"
                name: drv0
                desc: '''
                     Choose the driving strength of the pad. LSB = ~3mA
                '''
                swaccess: "rw"
                hwaccess: "hro"
                resval: "0"
            },
            {
                bits: "2"
                name: drv1
                desc: '''
                     Choose the driving strength of the pad. LSB = ~3mA
                '''
                swaccess: "rw"
                hwaccess: "hro"
                resval: "0"
            },
            {
                bits: "3"
                name: drv2
                desc: '''
                     Choose the driving strength of the pad. LSB = ~3mA
                '''
                swaccess: "rw"
                hwaccess: "hro"
                resval: "0"
            },
            {
                bits: "4"
                name: drv3
                desc: '''
                     Choose the driving strength of the pad. LSB = ~3mA
                '''
                swaccess: "rw"
                hwaccess: "hro"
                resval: "1"
            },
            {
                bits: "5"
                name: pull_en
                desc: '''
                     Enable pull up/down (depends on pull_sel) resistor, active-high
                '''
                swaccess: "rw"
                hwaccess: "hro"
                resval: "0"
            },
            {
                bits: "6"
                name: pull_sel
                desc: '''
                     1 -> use pull-up resistor (if pull_en == 1), 0 -> use pull-down resistor
                '''
                swaccess: "rw"
                hwaccess: "hro"
                resval: "0"
            },
            {
                bits: "7"
                name: ret_en
                desc: '''
                     Enable retention mode, active-high
                '''
                swaccess: "rw"
                hwaccess: "hro"
                resval: "0"
            },
            {
                bits: "8"
                name: st_en
                desc: '''
                     Schmitt-trigger enable, active high
                '''
                swaccess: "rw"
                hwaccess: "hro"
                resval: "0"
            },
            {
                bits: "9"
                name: tx_en
                desc: '''
                     TX driver enable, active low
                '''
                swaccess: "rw"
                hwaccess: "hro"
                resval: "0"
            },
          ]
      }

       {
          name: PAD_GPIO10_MUX_SEL
          desc: '''
              Pad signal port multiplex selection for pad pad_gpio10. The programmed value defines which port
              is connected to the pad.
          '''
          swaccess: "rw"
          hwaccess: "hro"
          resval: 1
          fields: [
              {
                  bits: "3:0"
                  enum: [
                      { value: "0", name: "register", desc: "Connects the Pad to the internal configuration register."}
                      { value: "1", name: "port_mram_debug_tm_signals_bank0_tm1", desc: "Connect port bank0_tm1 from port group mram_debug_tm_signals to this pad." }
                      { value: "2", name: "port_mram_debug_tm_signals_bank1_tm1", desc: "Connect port bank1_tm1 from port group mram_debug_tm_signals to this pad." }
                      { value: "3", name: "port_mram_debug_tm_signals_bank2_tm1", desc: "Connect port bank2_tm1 from port group mram_debug_tm_signals to this pad." }
                      { value: "4", name: "port_mram_debug_tm_signals_bank3_tm1", desc: "Connect port bank3_tm1 from port group mram_debug_tm_signals to this pad." }
                      { value: "5", name: "port_mram_debug_tm_signals_bank4_tm1", desc: "Connect port bank4_tm1 from port group mram_debug_tm_signals to this pad." }
                      { value: "6", name: "port_mram_debug_tm_signals_bank5_tm1", desc: "Connect port bank5_tm1 from port group mram_debug_tm_signals to this pad." }
                      { value: "7", name: "port_mram_debug_tm_signals_bank6_tm1", desc: "Connect port bank6_tm1 from port group mram_debug_tm_signals to this pad." }
                      { value: "8", name: "port_mram_debug_tm_signals_bank7_tm1", desc: "Connect port bank7_tm1 from port group mram_debug_tm_signals to this pad." }
                      { value: "9", name: "port_observables_s_cluster_rstn", desc: "Connect port s_cluster_rstn from port group observables to this pad." }
                      { value: "10", name: "port_observables_s_soc_rstn", desc: "Connect port s_soc_rstn from port group observables to this pad." }
                  ]
              }
          ]
      }

      {
          name: PAD_GPIO11_CFG
          desc: '''
            Pad signal configuration.
          '''
          swaccess: "rw"
          fields: [
            {
                bits: "0"
                name: chip2pad
                desc: '''
                     Connects to pad's TX driver
                '''
                swaccess: "rw"
                hwaccess: "hro"
                resval: "0"
            },
            {
                bits: "1"
                name: drv0
                desc: '''
                     Choose the driving strength of the pad. LSB = ~3mA
                '''
                swaccess: "rw"
                hwaccess: "hro"
                resval: "0"
            },
            {
                bits: "2"
                name: drv1
                desc: '''
                     Choose the driving strength of the pad. LSB = ~3mA
                '''
                swaccess: "rw"
                hwaccess: "hro"
                resval: "0"
            },
            {
                bits: "3"
                name: drv2
                desc: '''
                     Choose the driving strength of the pad. LSB = ~3mA
                '''
                swaccess: "rw"
                hwaccess: "hro"
                resval: "0"
            },
            {
                bits: "4"
                name: drv3
                desc: '''
                     Choose the driving strength of the pad. LSB = ~3mA
                '''
                swaccess: "rw"
                hwaccess: "hro"
                resval: "1"
            },
            {
                bits: "5"
                name: pull_en
                desc: '''
                     Enable pull up/down (depends on pull_sel) resistor, active-high
                '''
                swaccess: "rw"
                hwaccess: "hro"
                resval: "0"
            },
            {
                bits: "6"
                name: pull_sel
                desc: '''
                     1 -> use pull-up resistor (if pull_en == 1), 0 -> use pull-down resistor
                '''
                swaccess: "rw"
                hwaccess: "hro"
                resval: "0"
            },
            {
                bits: "7"
                name: ret_en
                desc: '''
                     Enable retention mode, active-high
                '''
                swaccess: "rw"
                hwaccess: "hro"
                resval: "0"
            },
            {
                bits: "8"
                name: st_en
                desc: '''
                     Schmitt-trigger enable, active high
                '''
                swaccess: "rw"
                hwaccess: "hro"
                resval: "0"
            },
            {
                bits: "9"
                name: tx_en
                desc: '''
                     TX driver enable, active low
                '''
                swaccess: "rw"
                hwaccess: "hro"
                resval: "0"
            },
          ]
      }

       {
          name: PAD_GPIO11_MUX_SEL
          desc: '''
              Pad signal port multiplex selection for pad pad_gpio11. The programmed value defines which port
              is connected to the pad.
          '''
          swaccess: "rw"
          hwaccess: "hro"
          resval: 1
          fields: [
              {
                  bits: "3:0"
                  enum: [
                      { value: "0", name: "register", desc: "Connects the Pad to the internal configuration register."}
                      { value: "1", name: "port_mram_debug_tm_signals_bank0_tm0", desc: "Connect port bank0_tm0 from port group mram_debug_tm_signals to this pad." }
                      { value: "2", name: "port_mram_debug_tm_signals_bank1_tm0", desc: "Connect port bank1_tm0 from port group mram_debug_tm_signals to this pad." }
                      { value: "3", name: "port_mram_debug_tm_signals_bank2_tm0", desc: "Connect port bank2_tm0 from port group mram_debug_tm_signals to this pad." }
                      { value: "4", name: "port_mram_debug_tm_signals_bank3_tm0", desc: "Connect port bank3_tm0 from port group mram_debug_tm_signals to this pad." }
                      { value: "5", name: "port_mram_debug_tm_signals_bank4_tm0", desc: "Connect port bank4_tm0 from port group mram_debug_tm_signals to this pad." }
                      { value: "6", name: "port_mram_debug_tm_signals_bank5_tm0", desc: "Connect port bank5_tm0 from port group mram_debug_tm_signals to this pad." }
                      { value: "7", name: "port_mram_debug_tm_signals_bank6_tm0", desc: "Connect port bank6_tm0 from port group mram_debug_tm_signals to this pad." }
                      { value: "8", name: "port_mram_debug_tm_signals_bank7_tm0", desc: "Connect port bank7_tm0 from port group mram_debug_tm_signals to this pad." }
                      { value: "9", name: "port_observables_s_cluster_rstn", desc: "Connect port s_cluster_rstn from port group observables to this pad." }
                      { value: "10", name: "port_observables_s_soc_rstn", desc: "Connect port s_soc_rstn from port group observables to this pad." }
                  ]
              }
          ]
      }

      {
          name: PAD_GPIO12_CFG
          desc: '''
            Pad signal configuration.
          '''
          swaccess: "rw"
          fields: [
            {
                bits: "0"
                name: chip2pad
                desc: '''
                     Connects to pad's TX driver
                '''
                swaccess: "rw"
                hwaccess: "hro"
                resval: "0"
            },
            {
                bits: "1"
                name: drv0
                desc: '''
                     Choose the driving strength of the pad. LSB = ~3mA
                '''
                swaccess: "rw"
                hwaccess: "hro"
                resval: "0"
            },
            {
                bits: "2"
                name: drv1
                desc: '''
                     Choose the driving strength of the pad. LSB = ~3mA
                '''
                swaccess: "rw"
                hwaccess: "hro"
                resval: "0"
            },
            {
                bits: "3"
                name: drv2
                desc: '''
                     Choose the driving strength of the pad. LSB = ~3mA
                '''
                swaccess: "rw"
                hwaccess: "hro"
                resval: "0"
            },
            {
                bits: "4"
                name: drv3
                desc: '''
                     Choose the driving strength of the pad. LSB = ~3mA
                '''
                swaccess: "rw"
                hwaccess: "hro"
                resval: "1"
            },
            {
                bits: "5"
                name: pull_en
                desc: '''
                     Enable pull up/down (depends on pull_sel) resistor, active-high
                '''
                swaccess: "rw"
                hwaccess: "hro"
                resval: "0"
            },
            {
                bits: "6"
                name: pull_sel
                desc: '''
                     1 -> use pull-up resistor (if pull_en == 1), 0 -> use pull-down resistor
                '''
                swaccess: "rw"
                hwaccess: "hro"
                resval: "0"
            },
            {
                bits: "7"
                name: ret_en
                desc: '''
                     Enable retention mode, active-high
                '''
                swaccess: "rw"
                hwaccess: "hro"
                resval: "0"
            },
            {
                bits: "8"
                name: st_en
                desc: '''
                     Schmitt-trigger enable, active high
                '''
                swaccess: "rw"
                hwaccess: "hro"
                resval: "0"
            },
            {
                bits: "9"
                name: tx_en
                desc: '''
                     TX driver enable, active low
                '''
                swaccess: "rw"
                hwaccess: "hro"
                resval: "0"
            },
          ]
      }

       {
          name: PAD_GPIO12_MUX_SEL
          desc: '''
              Pad signal port multiplex selection for pad pad_gpio12. The programmed value defines which port
              is connected to the pad.
          '''
          swaccess: "rw"
          hwaccess: "hro"
          resval: 1
          fields: [
              {
                  bits: "1:0"
                  enum: [
                      { value: "0", name: "register", desc: "Connects the Pad to the internal configuration register."}
                      { value: "1", name: "port_clocks_ref_clk", desc: "Connect port ref_clk from port group clocks to this pad." }
                      { value: "2", name: "port_observables_s_cluster_rstn", desc: "Connect port s_cluster_rstn from port group observables to this pad." }
                      { value: "3", name: "port_observables_s_soc_rstn", desc: "Connect port s_soc_rstn from port group observables to this pad." }
                  ]
              }
          ]
      }

      {
          name: PAD_GPIO13_CFG
          desc: '''
            Pad signal configuration.
          '''
          swaccess: "rw"
          fields: [
            {
                bits: "0"
                name: chip2pad
                desc: '''
                     Connects to pad's TX driver
                '''
                swaccess: "rw"
                hwaccess: "hro"
                resval: "0"
            },
            {
                bits: "1"
                name: drv0
                desc: '''
                     Choose the driving strength of the pad. LSB = ~3mA
                '''
                swaccess: "rw"
                hwaccess: "hro"
                resval: "0"
            },
            {
                bits: "2"
                name: drv1
                desc: '''
                     Choose the driving strength of the pad. LSB = ~3mA
                '''
                swaccess: "rw"
                hwaccess: "hro"
                resval: "0"
            },
            {
                bits: "3"
                name: drv2
                desc: '''
                     Choose the driving strength of the pad. LSB = ~3mA
                '''
                swaccess: "rw"
                hwaccess: "hro"
                resval: "0"
            },
            {
                bits: "4"
                name: drv3
                desc: '''
                     Choose the driving strength of the pad. LSB = ~3mA
                '''
                swaccess: "rw"
                hwaccess: "hro"
                resval: "1"
            },
            {
                bits: "5"
                name: pull_en
                desc: '''
                     Enable pull up/down (depends on pull_sel) resistor, active-high
                '''
                swaccess: "rw"
                hwaccess: "hro"
                resval: "0"
            },
            {
                bits: "6"
                name: pull_sel
                desc: '''
                     1 -> use pull-up resistor (if pull_en == 1), 0 -> use pull-down resistor
                '''
                swaccess: "rw"
                hwaccess: "hro"
                resval: "0"
            },
            {
                bits: "7"
                name: ret_en
                desc: '''
                     Enable retention mode, active-high
                '''
                swaccess: "rw"
                hwaccess: "hro"
                resval: "0"
            },
            {
                bits: "8"
                name: st_en
                desc: '''
                     Schmitt-trigger enable, active high
                '''
                swaccess: "rw"
                hwaccess: "hro"
                resval: "0"
            },
            {
                bits: "9"
                name: tx_en
                desc: '''
                     TX driver enable, active low
                '''
                swaccess: "rw"
                hwaccess: "hro"
                resval: "0"
            },
          ]
      }

       {
          name: PAD_GPIO13_MUX_SEL
          desc: '''
              Pad signal port multiplex selection for pad pad_gpio13. The programmed value defines which port
              is connected to the pad.
          '''
          swaccess: "rw"
          hwaccess: "hro"
          resval: 1
          fields: [
              {
                  bits: "1:0"
                  enum: [
                      { value: "0", name: "register", desc: "Connects the Pad to the internal configuration register."}
                      { value: "1", name: "port_clocks_soc_clk", desc: "Connect port soc_clk from port group clocks to this pad." }
                      { value: "2", name: "port_observables_s_cluster_rstn", desc: "Connect port s_cluster_rstn from port group observables to this pad." }
                      { value: "3", name: "port_observables_s_soc_rstn", desc: "Connect port s_soc_rstn from port group observables to this pad." }
                  ]
              }
          ]
      }

      {
          name: PAD_GPIO14_CFG
          desc: '''
            Pad signal configuration.
          '''
          swaccess: "rw"
          fields: [
            {
                bits: "0"
                name: chip2pad
                desc: '''
                     Connects to pad's TX driver
                '''
                swaccess: "rw"
                hwaccess: "hro"
                resval: "0"
            },
            {
                bits: "1"
                name: drv0
                desc: '''
                     Choose the driving strength of the pad. LSB = ~3mA
                '''
                swaccess: "rw"
                hwaccess: "hro"
                resval: "0"
            },
            {
                bits: "2"
                name: drv1
                desc: '''
                     Choose the driving strength of the pad. LSB = ~3mA
                '''
                swaccess: "rw"
                hwaccess: "hro"
                resval: "0"
            },
            {
                bits: "3"
                name: drv2
                desc: '''
                     Choose the driving strength of the pad. LSB = ~3mA
                '''
                swaccess: "rw"
                hwaccess: "hro"
                resval: "0"
            },
            {
                bits: "4"
                name: drv3
                desc: '''
                     Choose the driving strength of the pad. LSB = ~3mA
                '''
                swaccess: "rw"
                hwaccess: "hro"
                resval: "1"
            },
            {
                bits: "5"
                name: pull_en
                desc: '''
                     Enable pull up/down (depends on pull_sel) resistor, active-high
                '''
                swaccess: "rw"
                hwaccess: "hro"
                resval: "0"
            },
            {
                bits: "6"
                name: pull_sel
                desc: '''
                     1 -> use pull-up resistor (if pull_en == 1), 0 -> use pull-down resistor
                '''
                swaccess: "rw"
                hwaccess: "hro"
                resval: "0"
            },
            {
                bits: "7"
                name: ret_en
                desc: '''
                     Enable retention mode, active-high
                '''
                swaccess: "rw"
                hwaccess: "hro"
                resval: "0"
            },
            {
                bits: "8"
                name: st_en
                desc: '''
                     Schmitt-trigger enable, active high
                '''
                swaccess: "rw"
                hwaccess: "hro"
                resval: "0"
            },
            {
                bits: "9"
                name: tx_en
                desc: '''
                     TX driver enable, active low
                '''
                swaccess: "rw"
                hwaccess: "hro"
                resval: "0"
            },
          ]
      }

       {
          name: PAD_GPIO14_MUX_SEL
          desc: '''
              Pad signal port multiplex selection for pad pad_gpio14. The programmed value defines which port
              is connected to the pad.
          '''
          swaccess: "rw"
          hwaccess: "hro"
          resval: 1
          fields: [
              {
                  bits: "1:0"
                  enum: [
                      { value: "0", name: "register", desc: "Connects the Pad to the internal configuration register."}
                      { value: "1", name: "port_clocks_soc_clk_bypass_en", desc: "Connect port soc_clk_bypass_en from port group clocks to this pad." }
                      { value: "2", name: "port_observables_s_cluster_rstn", desc: "Connect port s_cluster_rstn from port group observables to this pad." }
                      { value: "3", name: "port_observables_s_soc_rstn", desc: "Connect port s_soc_rstn from port group observables to this pad." }
                  ]
              }
          ]
      }

      {
          name: PAD_GPIO15_CFG
          desc: '''
            Pad signal configuration.
          '''
          swaccess: "rw"
          fields: [
            {
                bits: "0"
                name: chip2pad
                desc: '''
                     Connects to pad's TX driver
                '''
                swaccess: "rw"
                hwaccess: "hro"
                resval: "0"
            },
            {
                bits: "1"
                name: drv0
                desc: '''
                     Choose the driving strength of the pad. LSB = ~3mA
                '''
                swaccess: "rw"
                hwaccess: "hro"
                resval: "0"
            },
            {
                bits: "2"
                name: drv1
                desc: '''
                     Choose the driving strength of the pad. LSB = ~3mA
                '''
                swaccess: "rw"
                hwaccess: "hro"
                resval: "0"
            },
            {
                bits: "3"
                name: drv2
                desc: '''
                     Choose the driving strength of the pad. LSB = ~3mA
                '''
                swaccess: "rw"
                hwaccess: "hro"
                resval: "0"
            },
            {
                bits: "4"
                name: drv3
                desc: '''
                     Choose the driving strength of the pad. LSB = ~3mA
                '''
                swaccess: "rw"
                hwaccess: "hro"
                resval: "1"
            },
            {
                bits: "5"
                name: pull_en
                desc: '''
                     Enable pull up/down (depends on pull_sel) resistor, active-high
                '''
                swaccess: "rw"
                hwaccess: "hro"
                resval: "0"
            },
            {
                bits: "6"
                name: pull_sel
                desc: '''
                     1 -> use pull-up resistor (if pull_en == 1), 0 -> use pull-down resistor
                '''
                swaccess: "rw"
                hwaccess: "hro"
                resval: "0"
            },
            {
                bits: "7"
                name: ret_en
                desc: '''
                     Enable retention mode, active-high
                '''
                swaccess: "rw"
                hwaccess: "hro"
                resval: "0"
            },
            {
                bits: "8"
                name: st_en
                desc: '''
                     Schmitt-trigger enable, active high
                '''
                swaccess: "rw"
                hwaccess: "hro"
                resval: "0"
            },
            {
                bits: "9"
                name: tx_en
                desc: '''
                     TX driver enable, active low
                '''
                swaccess: "rw"
                hwaccess: "hro"
                resval: "0"
            },
          ]
      }

       {
          name: PAD_GPIO15_MUX_SEL
          desc: '''
              Pad signal port multiplex selection for pad pad_gpio15. The programmed value defines which port
              is connected to the pad.
          '''
          swaccess: "rw"
          hwaccess: "hro"
          resval: 1
          fields: [
              {
                  bits: "1:0"
                  enum: [
                      { value: "0", name: "register", desc: "Connects the Pad to the internal configuration register."}
                      { value: "1", name: "port_clocks_per_clk", desc: "Connect port per_clk from port group clocks to this pad." }
                      { value: "2", name: "port_observables_s_cluster_rstn", desc: "Connect port s_cluster_rstn from port group observables to this pad." }
                      { value: "3", name: "port_observables_s_soc_rstn", desc: "Connect port s_soc_rstn from port group observables to this pad." }
                  ]
              }
          ]
      }

      {
          name: PAD_GPIO16_CFG
          desc: '''
            Pad signal configuration.
          '''
          swaccess: "rw"
          fields: [
            {
                bits: "0"
                name: chip2pad
                desc: '''
                     Connects to pad's TX driver
                '''
                swaccess: "rw"
                hwaccess: "hro"
                resval: "0"
            },
            {
                bits: "1"
                name: drv0
                desc: '''
                     Choose the driving strength of the pad. LSB = ~3mA
                '''
                swaccess: "rw"
                hwaccess: "hro"
                resval: "0"
            },
            {
                bits: "2"
                name: drv1
                desc: '''
                     Choose the driving strength of the pad. LSB = ~3mA
                '''
                swaccess: "rw"
                hwaccess: "hro"
                resval: "0"
            },
            {
                bits: "3"
                name: drv2
                desc: '''
                     Choose the driving strength of the pad. LSB = ~3mA
                '''
                swaccess: "rw"
                hwaccess: "hro"
                resval: "0"
            },
            {
                bits: "4"
                name: drv3
                desc: '''
                     Choose the driving strength of the pad. LSB = ~3mA
                '''
                swaccess: "rw"
                hwaccess: "hro"
                resval: "1"
            },
            {
                bits: "5"
                name: pull_en
                desc: '''
                     Enable pull up/down (depends on pull_sel) resistor, active-high
                '''
                swaccess: "rw"
                hwaccess: "hro"
                resval: "0"
            },
            {
                bits: "6"
                name: pull_sel
                desc: '''
                     1 -> use pull-up resistor (if pull_en == 1), 0 -> use pull-down resistor
                '''
                swaccess: "rw"
                hwaccess: "hro"
                resval: "0"
            },
            {
                bits: "7"
                name: ret_en
                desc: '''
                     Enable retention mode, active-high
                '''
                swaccess: "rw"
                hwaccess: "hro"
                resval: "0"
            },
            {
                bits: "8"
                name: st_en
                desc: '''
                     Schmitt-trigger enable, active high
                '''
                swaccess: "rw"
                hwaccess: "hro"
                resval: "0"
            },
            {
                bits: "9"
                name: tx_en
                desc: '''
                     TX driver enable, active low
                '''
                swaccess: "rw"
                hwaccess: "hro"
                resval: "0"
            },
          ]
      }

       {
          name: PAD_GPIO16_MUX_SEL
          desc: '''
              Pad signal port multiplex selection for pad pad_gpio16. The programmed value defines which port
              is connected to the pad.
          '''
          swaccess: "rw"
          hwaccess: "hro"
          resval: 1
          fields: [
              {
                  bits: "1:0"
                  enum: [
                      { value: "0", name: "register", desc: "Connects the Pad to the internal configuration register."}
                      { value: "1", name: "port_clocks_per_clk_bypass_en", desc: "Connect port per_clk_bypass_en from port group clocks to this pad." }
                      { value: "2", name: "port_observables_s_cluster_rstn", desc: "Connect port s_cluster_rstn from port group observables to this pad." }
                      { value: "3", name: "port_observables_s_soc_rstn", desc: "Connect port s_soc_rstn from port group observables to this pad." }
                  ]
              }
          ]
      }

      {
          name: PAD_GPIO17_CFG
          desc: '''
            Pad signal configuration.
          '''
          swaccess: "rw"
          fields: [
            {
                bits: "0"
                name: chip2pad
                desc: '''
                     Connects to pad's TX driver
                '''
                swaccess: "rw"
                hwaccess: "hro"
                resval: "0"
            },
            {
                bits: "1"
                name: drv0
                desc: '''
                     Choose the driving strength of the pad. LSB = ~3mA
                '''
                swaccess: "rw"
                hwaccess: "hro"
                resval: "0"
            },
            {
                bits: "2"
                name: drv1
                desc: '''
                     Choose the driving strength of the pad. LSB = ~3mA
                '''
                swaccess: "rw"
                hwaccess: "hro"
                resval: "0"
            },
            {
                bits: "3"
                name: drv2
                desc: '''
                     Choose the driving strength of the pad. LSB = ~3mA
                '''
                swaccess: "rw"
                hwaccess: "hro"
                resval: "0"
            },
            {
                bits: "4"
                name: drv3
                desc: '''
                     Choose the driving strength of the pad. LSB = ~3mA
                '''
                swaccess: "rw"
                hwaccess: "hro"
                resval: "1"
            },
            {
                bits: "5"
                name: pull_en
                desc: '''
                     Enable pull up/down (depends on pull_sel) resistor, active-high
                '''
                swaccess: "rw"
                hwaccess: "hro"
                resval: "0"
            },
            {
                bits: "6"
                name: pull_sel
                desc: '''
                     1 -> use pull-up resistor (if pull_en == 1), 0 -> use pull-down resistor
                '''
                swaccess: "rw"
                hwaccess: "hro"
                resval: "0"
            },
            {
                bits: "7"
                name: ret_en
                desc: '''
                     Enable retention mode, active-high
                '''
                swaccess: "rw"
                hwaccess: "hro"
                resval: "0"
            },
            {
                bits: "8"
                name: st_en
                desc: '''
                     Schmitt-trigger enable, active high
                '''
                swaccess: "rw"
                hwaccess: "hro"
                resval: "0"
            },
            {
                bits: "9"
                name: tx_en
                desc: '''
                     TX driver enable, active low
                '''
                swaccess: "rw"
                hwaccess: "hro"
                resval: "0"
            },
          ]
      }

       {
          name: PAD_GPIO17_MUX_SEL
          desc: '''
              Pad signal port multiplex selection for pad pad_gpio17. The programmed value defines which port
              is connected to the pad.
          '''
          swaccess: "rw"
          hwaccess: "hro"
          resval: 1
          fields: [
              {
                  bits: "1:0"
                  enum: [
                      { value: "0", name: "register", desc: "Connects the Pad to the internal configuration register."}
                      { value: "1", name: "port_clocks_cluster_clk", desc: "Connect port cluster_clk from port group clocks to this pad." }
                      { value: "2", name: "port_observables_s_cluster_rstn", desc: "Connect port s_cluster_rstn from port group observables to this pad." }
                      { value: "3", name: "port_observables_s_soc_rstn", desc: "Connect port s_soc_rstn from port group observables to this pad." }
                  ]
              }
          ]
      }

      {
          name: PAD_GPIO18_CFG
          desc: '''
            Pad signal configuration.
          '''
          swaccess: "rw"
          fields: [
            {
                bits: "0"
                name: chip2pad
                desc: '''
                     Connects to pad's TX driver
                '''
                swaccess: "rw"
                hwaccess: "hro"
                resval: "0"
            },
            {
                bits: "1"
                name: drv0
                desc: '''
                     Choose the driving strength of the pad. LSB = ~3mA
                '''
                swaccess: "rw"
                hwaccess: "hro"
                resval: "0"
            },
            {
                bits: "2"
                name: drv1
                desc: '''
                     Choose the driving strength of the pad. LSB = ~3mA
                '''
                swaccess: "rw"
                hwaccess: "hro"
                resval: "0"
            },
            {
                bits: "3"
                name: drv2
                desc: '''
                     Choose the driving strength of the pad. LSB = ~3mA
                '''
                swaccess: "rw"
                hwaccess: "hro"
                resval: "0"
            },
            {
                bits: "4"
                name: drv3
                desc: '''
                     Choose the driving strength of the pad. LSB = ~3mA
                '''
                swaccess: "rw"
                hwaccess: "hro"
                resval: "1"
            },
            {
                bits: "5"
                name: pull_en
                desc: '''
                     Enable pull up/down (depends on pull_sel) resistor, active-high
                '''
                swaccess: "rw"
                hwaccess: "hro"
                resval: "0"
            },
            {
                bits: "6"
                name: pull_sel
                desc: '''
                     1 -> use pull-up resistor (if pull_en == 1), 0 -> use pull-down resistor
                '''
                swaccess: "rw"
                hwaccess: "hro"
                resval: "0"
            },
            {
                bits: "7"
                name: ret_en
                desc: '''
                     Enable retention mode, active-high
                '''
                swaccess: "rw"
                hwaccess: "hro"
                resval: "0"
            },
            {
                bits: "8"
                name: st_en
                desc: '''
                     Schmitt-trigger enable, active high
                '''
                swaccess: "rw"
                hwaccess: "hro"
                resval: "0"
            },
            {
                bits: "9"
                name: tx_en
                desc: '''
                     TX driver enable, active low
                '''
                swaccess: "rw"
                hwaccess: "hro"
                resval: "0"
            },
          ]
      }

       {
          name: PAD_GPIO18_MUX_SEL
          desc: '''
              Pad signal port multiplex selection for pad pad_gpio18. The programmed value defines which port
              is connected to the pad.
          '''
          swaccess: "rw"
          hwaccess: "hro"
          resval: 1
          fields: [
              {
                  bits: "1:0"
                  enum: [
                      { value: "0", name: "register", desc: "Connects the Pad to the internal configuration register."}
                      { value: "1", name: "port_clocks_cluster_clk_bypass_en", desc: "Connect port cluster_clk_bypass_en from port group clocks to this pad." }
                      { value: "2", name: "port_observables_s_cluster_rstn", desc: "Connect port s_cluster_rstn from port group observables to this pad." }
                      { value: "3", name: "port_observables_s_soc_rstn", desc: "Connect port s_soc_rstn from port group observables to this pad." }
                  ]
              }
          ]
      }

      {
          name: PAD_GPIO19_CFG
          desc: '''
            Pad signal configuration.
          '''
          swaccess: "rw"
          fields: [
            {
                bits: "0"
                name: chip2pad
                desc: '''
                     Connects to pad's TX driver
                '''
                swaccess: "rw"
                hwaccess: "hro"
                resval: "0"
            },
            {
                bits: "1"
                name: drv0
                desc: '''
                     Choose the driving strength of the pad. LSB = ~3mA
                '''
                swaccess: "rw"
                hwaccess: "hro"
                resval: "0"
            },
            {
                bits: "2"
                name: drv1
                desc: '''
                     Choose the driving strength of the pad. LSB = ~3mA
                '''
                swaccess: "rw"
                hwaccess: "hro"
                resval: "0"
            },
            {
                bits: "3"
                name: drv2
                desc: '''
                     Choose the driving strength of the pad. LSB = ~3mA
                '''
                swaccess: "rw"
                hwaccess: "hro"
                resval: "0"
            },
            {
                bits: "4"
                name: drv3
                desc: '''
                     Choose the driving strength of the pad. LSB = ~3mA
                '''
                swaccess: "rw"
                hwaccess: "hro"
                resval: "1"
            },
            {
                bits: "5"
                name: pull_en
                desc: '''
                     Enable pull up/down (depends on pull_sel) resistor, active-high
                '''
                swaccess: "rw"
                hwaccess: "hro"
                resval: "0"
            },
            {
                bits: "6"
                name: pull_sel
                desc: '''
                     1 -> use pull-up resistor (if pull_en == 1), 0 -> use pull-down resistor
                '''
                swaccess: "rw"
                hwaccess: "hro"
                resval: "0"
            },
            {
                bits: "7"
                name: ret_en
                desc: '''
                     Enable retention mode, active-high
                '''
                swaccess: "rw"
                hwaccess: "hro"
                resval: "0"
            },
            {
                bits: "8"
                name: st_en
                desc: '''
                     Schmitt-trigger enable, active high
                '''
                swaccess: "rw"
                hwaccess: "hro"
                resval: "0"
            },
            {
                bits: "9"
                name: tx_en
                desc: '''
                     TX driver enable, active low
                '''
                swaccess: "rw"
                hwaccess: "hro"
                resval: "0"
            },
          ]
      }

       {
          name: PAD_GPIO19_MUX_SEL
          desc: '''
              Pad signal port multiplex selection for pad pad_gpio19. The programmed value defines which port
              is connected to the pad.
          '''
          swaccess: "rw"
          hwaccess: "hro"
          resval: 0
          fields: [
              {
                  bits: "1:0"
                  enum: [
                      { value: "0", name: "register", desc: "Connects the Pad to the internal configuration register."}
                      { value: "1", name: "port_observables_s_cluster_rstn", desc: "Connect port s_cluster_rstn from port group observables to this pad." }
                      { value: "2", name: "port_observables_s_soc_rstn", desc: "Connect port s_soc_rstn from port group observables to this pad." }
                  ]
              }
          ]
      }

      {
          name: PAD_GPIO20_CFG
          desc: '''
            Pad signal configuration.
          '''
          swaccess: "rw"
          fields: [
            {
                bits: "0"
                name: chip2pad
                desc: '''
                     Connects to pad's TX driver
                '''
                swaccess: "rw"
                hwaccess: "hro"
                resval: "0"
            },
            {
                bits: "1"
                name: drv0
                desc: '''
                     Choose the driving strength of the pad. LSB = ~3mA
                '''
                swaccess: "rw"
                hwaccess: "hro"
                resval: "0"
            },
            {
                bits: "2"
                name: drv1
                desc: '''
                     Choose the driving strength of the pad. LSB = ~3mA
                '''
                swaccess: "rw"
                hwaccess: "hro"
                resval: "0"
            },
            {
                bits: "3"
                name: drv2
                desc: '''
                     Choose the driving strength of the pad. LSB = ~3mA
                '''
                swaccess: "rw"
                hwaccess: "hro"
                resval: "0"
            },
            {
                bits: "4"
                name: drv3
                desc: '''
                     Choose the driving strength of the pad. LSB = ~3mA
                '''
                swaccess: "rw"
                hwaccess: "hro"
                resval: "1"
            },
            {
                bits: "5"
                name: pull_en
                desc: '''
                     Enable pull up/down (depends on pull_sel) resistor, active-high
                '''
                swaccess: "rw"
                hwaccess: "hro"
                resval: "0"
            },
            {
                bits: "6"
                name: pull_sel
                desc: '''
                     1 -> use pull-up resistor (if pull_en == 1), 0 -> use pull-down resistor
                '''
                swaccess: "rw"
                hwaccess: "hro"
                resval: "0"
            },
            {
                bits: "7"
                name: ret_en
                desc: '''
                     Enable retention mode, active-high
                '''
                swaccess: "rw"
                hwaccess: "hro"
                resval: "0"
            },
            {
                bits: "8"
                name: st_en
                desc: '''
                     Schmitt-trigger enable, active high
                '''
                swaccess: "rw"
                hwaccess: "hro"
                resval: "0"
            },
            {
                bits: "9"
                name: tx_en
                desc: '''
                     TX driver enable, active low
                '''
                swaccess: "rw"
                hwaccess: "hro"
                resval: "0"
            },
          ]
      }

       {
          name: PAD_GPIO20_MUX_SEL
          desc: '''
              Pad signal port multiplex selection for pad pad_gpio20. The programmed value defines which port
              is connected to the pad.
          '''
          swaccess: "rw"
          hwaccess: "hro"
          resval: 0
          fields: [
              {
                  bits: "1:0"
                  enum: [
                      { value: "0", name: "register", desc: "Connects the Pad to the internal configuration register."}
                      { value: "1", name: "port_observables_s_cluster_rstn", desc: "Connect port s_cluster_rstn from port group observables to this pad." }
                      { value: "2", name: "port_observables_s_soc_rstn", desc: "Connect port s_soc_rstn from port group observables to this pad." }
                  ]
              }
          ]
      }

      {
          name: PAD_GPIO21_CFG
          desc: '''
            Pad signal configuration.
          '''
          swaccess: "rw"
          fields: [
            {
                bits: "0"
                name: chip2pad
                desc: '''
                     Connects to pad's TX driver
                '''
                swaccess: "rw"
                hwaccess: "hro"
                resval: "0"
            },
            {
                bits: "1"
                name: drv0
                desc: '''
                     Choose the driving strength of the pad. LSB = ~3mA
                '''
                swaccess: "rw"
                hwaccess: "hro"
                resval: "0"
            },
            {
                bits: "2"
                name: drv1
                desc: '''
                     Choose the driving strength of the pad. LSB = ~3mA
                '''
                swaccess: "rw"
                hwaccess: "hro"
                resval: "0"
            },
            {
                bits: "3"
                name: drv2
                desc: '''
                     Choose the driving strength of the pad. LSB = ~3mA
                '''
                swaccess: "rw"
                hwaccess: "hro"
                resval: "0"
            },
            {
                bits: "4"
                name: drv3
                desc: '''
                     Choose the driving strength of the pad. LSB = ~3mA
                '''
                swaccess: "rw"
                hwaccess: "hro"
                resval: "1"
            },
            {
                bits: "5"
                name: pull_en
                desc: '''
                     Enable pull up/down (depends on pull_sel) resistor, active-high
                '''
                swaccess: "rw"
                hwaccess: "hro"
                resval: "0"
            },
            {
                bits: "6"
                name: pull_sel
                desc: '''
                     1 -> use pull-up resistor (if pull_en == 1), 0 -> use pull-down resistor
                '''
                swaccess: "rw"
                hwaccess: "hro"
                resval: "0"
            },
            {
                bits: "7"
                name: ret_en
                desc: '''
                     Enable retention mode, active-high
                '''
                swaccess: "rw"
                hwaccess: "hro"
                resval: "0"
            },
            {
                bits: "8"
                name: st_en
                desc: '''
                     Schmitt-trigger enable, active high
                '''
                swaccess: "rw"
                hwaccess: "hro"
                resval: "0"
            },
            {
                bits: "9"
                name: tx_en
                desc: '''
                     TX driver enable, active low
                '''
                swaccess: "rw"
                hwaccess: "hro"
                resval: "0"
            },
          ]
      }

       {
          name: PAD_GPIO21_MUX_SEL
          desc: '''
              Pad signal port multiplex selection for pad pad_gpio21. The programmed value defines which port
              is connected to the pad.
          '''
          swaccess: "rw"
          hwaccess: "hro"
          resval: 0
          fields: [
              {
                  bits: "1:0"
                  enum: [
                      { value: "0", name: "register", desc: "Connects the Pad to the internal configuration register."}
                      { value: "1", name: "port_observables_s_cluster_rstn", desc: "Connect port s_cluster_rstn from port group observables to this pad." }
                      { value: "2", name: "port_observables_s_soc_rstn", desc: "Connect port s_soc_rstn from port group observables to this pad." }
                  ]
              }
          ]
      }

      {
          name: PAD_GPIO22_CFG
          desc: '''
            Pad signal configuration.
          '''
          swaccess: "rw"
          fields: [
            {
                bits: "0"
                name: chip2pad
                desc: '''
                     Connects to pad's TX driver
                '''
                swaccess: "rw"
                hwaccess: "hro"
                resval: "0"
            },
            {
                bits: "1"
                name: drv0
                desc: '''
                     Choose the driving strength of the pad. LSB = ~3mA
                '''
                swaccess: "rw"
                hwaccess: "hro"
                resval: "0"
            },
            {
                bits: "2"
                name: drv1
                desc: '''
                     Choose the driving strength of the pad. LSB = ~3mA
                '''
                swaccess: "rw"
                hwaccess: "hro"
                resval: "0"
            },
            {
                bits: "3"
                name: drv2
                desc: '''
                     Choose the driving strength of the pad. LSB = ~3mA
                '''
                swaccess: "rw"
                hwaccess: "hro"
                resval: "0"
            },
            {
                bits: "4"
                name: drv3
                desc: '''
                     Choose the driving strength of the pad. LSB = ~3mA
                '''
                swaccess: "rw"
                hwaccess: "hro"
                resval: "1"
            },
            {
                bits: "5"
                name: pull_en
                desc: '''
                     Enable pull up/down (depends on pull_sel) resistor, active-high
                '''
                swaccess: "rw"
                hwaccess: "hro"
                resval: "0"
            },
            {
                bits: "6"
                name: pull_sel
                desc: '''
                     1 -> use pull-up resistor (if pull_en == 1), 0 -> use pull-down resistor
                '''
                swaccess: "rw"
                hwaccess: "hro"
                resval: "0"
            },
            {
                bits: "7"
                name: ret_en
                desc: '''
                     Enable retention mode, active-high
                '''
                swaccess: "rw"
                hwaccess: "hro"
                resval: "0"
            },
            {
                bits: "8"
                name: st_en
                desc: '''
                     Schmitt-trigger enable, active high
                '''
                swaccess: "rw"
                hwaccess: "hro"
                resval: "0"
            },
            {
                bits: "9"
                name: tx_en
                desc: '''
                     TX driver enable, active low
                '''
                swaccess: "rw"
                hwaccess: "hro"
                resval: "0"
            },
          ]
      }

       {
          name: PAD_GPIO22_MUX_SEL
          desc: '''
              Pad signal port multiplex selection for pad pad_gpio22. The programmed value defines which port
              is connected to the pad.
          '''
          swaccess: "rw"
          hwaccess: "hro"
          resval: 0
          fields: [
              {
                  bits: "1:0"
                  enum: [
                      { value: "0", name: "register", desc: "Connects the Pad to the internal configuration register."}
                      { value: "1", name: "port_observables_s_cluster_rstn", desc: "Connect port s_cluster_rstn from port group observables to this pad." }
                      { value: "2", name: "port_observables_s_soc_rstn", desc: "Connect port s_soc_rstn from port group observables to this pad." }
                  ]
              }
          ]
      }

      {
          name: PAD_GPIO23_CFG
          desc: '''
            Pad signal configuration.
          '''
          swaccess: "rw"
          fields: [
            {
                bits: "0"
                name: chip2pad
                desc: '''
                     Connects to pad's TX driver
                '''
                swaccess: "rw"
                hwaccess: "hro"
                resval: "0"
            },
            {
                bits: "1"
                name: drv0
                desc: '''
                     Choose the driving strength of the pad. LSB = ~3mA
                '''
                swaccess: "rw"
                hwaccess: "hro"
                resval: "0"
            },
            {
                bits: "2"
                name: drv1
                desc: '''
                     Choose the driving strength of the pad. LSB = ~3mA
                '''
                swaccess: "rw"
                hwaccess: "hro"
                resval: "0"
            },
            {
                bits: "3"
                name: drv2
                desc: '''
                     Choose the driving strength of the pad. LSB = ~3mA
                '''
                swaccess: "rw"
                hwaccess: "hro"
                resval: "0"
            },
            {
                bits: "4"
                name: drv3
                desc: '''
                     Choose the driving strength of the pad. LSB = ~3mA
                '''
                swaccess: "rw"
                hwaccess: "hro"
                resval: "1"
            },
            {
                bits: "5"
                name: pull_en
                desc: '''
                     Enable pull up/down (depends on pull_sel) resistor, active-high
                '''
                swaccess: "rw"
                hwaccess: "hro"
                resval: "0"
            },
            {
                bits: "6"
                name: pull_sel
                desc: '''
                     1 -> use pull-up resistor (if pull_en == 1), 0 -> use pull-down resistor
                '''
                swaccess: "rw"
                hwaccess: "hro"
                resval: "0"
            },
            {
                bits: "7"
                name: ret_en
                desc: '''
                     Enable retention mode, active-high
                '''
                swaccess: "rw"
                hwaccess: "hro"
                resval: "0"
            },
            {
                bits: "8"
                name: st_en
                desc: '''
                     Schmitt-trigger enable, active high
                '''
                swaccess: "rw"
                hwaccess: "hro"
                resval: "0"
            },
            {
                bits: "9"
                name: tx_en
                desc: '''
                     TX driver enable, active low
                '''
                swaccess: "rw"
                hwaccess: "hro"
                resval: "0"
            },
          ]
      }

       {
          name: PAD_GPIO23_MUX_SEL
          desc: '''
              Pad signal port multiplex selection for pad pad_gpio23. The programmed value defines which port
              is connected to the pad.
          '''
          swaccess: "rw"
          hwaccess: "hro"
          resval: 0
          fields: [
              {
                  bits: "1:0"
                  enum: [
                      { value: "0", name: "register", desc: "Connects the Pad to the internal configuration register."}
                      { value: "1", name: "port_observables_s_cluster_rstn", desc: "Connect port s_cluster_rstn from port group observables to this pad." }
                      { value: "2", name: "port_observables_s_soc_rstn", desc: "Connect port s_soc_rstn from port group observables to this pad." }
                  ]
              }
          ]
      }

      {
          name: PAD_GPIO24_CFG
          desc: '''
            Pad signal configuration.
          '''
          swaccess: "rw"
          fields: [
            {
                bits: "0"
                name: chip2pad
                desc: '''
                     Connects to pad's TX driver
                '''
                swaccess: "rw"
                hwaccess: "hro"
                resval: "0"
            },
            {
                bits: "1"
                name: drv0
                desc: '''
                     Choose the driving strength of the pad. LSB = ~3mA
                '''
                swaccess: "rw"
                hwaccess: "hro"
                resval: "0"
            },
            {
                bits: "2"
                name: drv1
                desc: '''
                     Choose the driving strength of the pad. LSB = ~3mA
                '''
                swaccess: "rw"
                hwaccess: "hro"
                resval: "0"
            },
            {
                bits: "3"
                name: drv2
                desc: '''
                     Choose the driving strength of the pad. LSB = ~3mA
                '''
                swaccess: "rw"
                hwaccess: "hro"
                resval: "0"
            },
            {
                bits: "4"
                name: drv3
                desc: '''
                     Choose the driving strength of the pad. LSB = ~3mA
                '''
                swaccess: "rw"
                hwaccess: "hro"
                resval: "1"
            },
            {
                bits: "5"
                name: pull_en
                desc: '''
                     Enable pull up/down (depends on pull_sel) resistor, active-high
                '''
                swaccess: "rw"
                hwaccess: "hro"
                resval: "0"
            },
            {
                bits: "6"
                name: pull_sel
                desc: '''
                     1 -> use pull-up resistor (if pull_en == 1), 0 -> use pull-down resistor
                '''
                swaccess: "rw"
                hwaccess: "hro"
                resval: "0"
            },
            {
                bits: "7"
                name: ret_en
                desc: '''
                     Enable retention mode, active-high
                '''
                swaccess: "rw"
                hwaccess: "hro"
                resval: "0"
            },
            {
                bits: "8"
                name: st_en
                desc: '''
                     Schmitt-trigger enable, active high
                '''
                swaccess: "rw"
                hwaccess: "hro"
                resval: "0"
            },
            {
                bits: "9"
                name: tx_en
                desc: '''
                     TX driver enable, active low
                '''
                swaccess: "rw"
                hwaccess: "hro"
                resval: "0"
            },
          ]
      }

       {
          name: PAD_GPIO24_MUX_SEL
          desc: '''
              Pad signal port multiplex selection for pad pad_gpio24. The programmed value defines which port
              is connected to the pad.
          '''
          swaccess: "rw"
          hwaccess: "hro"
          resval: 0
          fields: [
              {
                  bits: "1:0"
                  enum: [
                      { value: "0", name: "register", desc: "Connects the Pad to the internal configuration register."}
                      { value: "1", name: "port_observables_s_cluster_rstn", desc: "Connect port s_cluster_rstn from port group observables to this pad." }
                      { value: "2", name: "port_observables_s_soc_rstn", desc: "Connect port s_soc_rstn from port group observables to this pad." }
                  ]
              }
          ]
      }

      {
          name: PAD_GPIO25_CFG
          desc: '''
            Pad signal configuration.
          '''
          swaccess: "rw"
          fields: [
            {
                bits: "0"
                name: chip2pad
                desc: '''
                     Connects to pad's TX driver
                '''
                swaccess: "rw"
                hwaccess: "hro"
                resval: "0"
            },
            {
                bits: "1"
                name: drv0
                desc: '''
                     Choose the driving strength of the pad. LSB = ~3mA
                '''
                swaccess: "rw"
                hwaccess: "hro"
                resval: "0"
            },
            {
                bits: "2"
                name: drv1
                desc: '''
                     Choose the driving strength of the pad. LSB = ~3mA
                '''
                swaccess: "rw"
                hwaccess: "hro"
                resval: "0"
            },
            {
                bits: "3"
                name: drv2
                desc: '''
                     Choose the driving strength of the pad. LSB = ~3mA
                '''
                swaccess: "rw"
                hwaccess: "hro"
                resval: "0"
            },
            {
                bits: "4"
                name: drv3
                desc: '''
                     Choose the driving strength of the pad. LSB = ~3mA
                '''
                swaccess: "rw"
                hwaccess: "hro"
                resval: "1"
            },
            {
                bits: "5"
                name: pull_en
                desc: '''
                     Enable pull up/down (depends on pull_sel) resistor, active-high
                '''
                swaccess: "rw"
                hwaccess: "hro"
                resval: "0"
            },
            {
                bits: "6"
                name: pull_sel
                desc: '''
                     1 -> use pull-up resistor (if pull_en == 1), 0 -> use pull-down resistor
                '''
                swaccess: "rw"
                hwaccess: "hro"
                resval: "0"
            },
            {
                bits: "7"
                name: ret_en
                desc: '''
                     Enable retention mode, active-high
                '''
                swaccess: "rw"
                hwaccess: "hro"
                resval: "0"
            },
            {
                bits: "8"
                name: st_en
                desc: '''
                     Schmitt-trigger enable, active high
                '''
                swaccess: "rw"
                hwaccess: "hro"
                resval: "0"
            },
            {
                bits: "9"
                name: tx_en
                desc: '''
                     TX driver enable, active low
                '''
                swaccess: "rw"
                hwaccess: "hro"
                resval: "0"
            },
          ]
      }

       {
          name: PAD_GPIO25_MUX_SEL
          desc: '''
              Pad signal port multiplex selection for pad pad_gpio25. The programmed value defines which port
              is connected to the pad.
          '''
          swaccess: "rw"
          hwaccess: "hro"
          resval: 0
          fields: [
              {
                  bits: "1:0"
                  enum: [
                      { value: "0", name: "register", desc: "Connects the Pad to the internal configuration register."}
                      { value: "1", name: "port_observables_s_cluster_rstn", desc: "Connect port s_cluster_rstn from port group observables to this pad." }
                      { value: "2", name: "port_observables_s_soc_rstn", desc: "Connect port s_soc_rstn from port group observables to this pad." }
                  ]
              }
          ]
      }

      {
          name: PAD_GPIO26_CFG
          desc: '''
            Pad signal configuration.
          '''
          swaccess: "rw"
          fields: [
            {
                bits: "0"
                name: chip2pad
                desc: '''
                     Connects to pad's TX driver
                '''
                swaccess: "rw"
                hwaccess: "hro"
                resval: "0"
            },
            {
                bits: "1"
                name: drv0
                desc: '''
                     Choose the driving strength of the pad. LSB = ~3mA
                '''
                swaccess: "rw"
                hwaccess: "hro"
                resval: "0"
            },
            {
                bits: "2"
                name: drv1
                desc: '''
                     Choose the driving strength of the pad. LSB = ~3mA
                '''
                swaccess: "rw"
                hwaccess: "hro"
                resval: "0"
            },
            {
                bits: "3"
                name: drv2
                desc: '''
                     Choose the driving strength of the pad. LSB = ~3mA
                '''
                swaccess: "rw"
                hwaccess: "hro"
                resval: "0"
            },
            {
                bits: "4"
                name: drv3
                desc: '''
                     Choose the driving strength of the pad. LSB = ~3mA
                '''
                swaccess: "rw"
                hwaccess: "hro"
                resval: "1"
            },
            {
                bits: "5"
                name: pull_en
                desc: '''
                     Enable pull up/down (depends on pull_sel) resistor, active-high
                '''
                swaccess: "rw"
                hwaccess: "hro"
                resval: "0"
            },
            {
                bits: "6"
                name: pull_sel
                desc: '''
                     1 -> use pull-up resistor (if pull_en == 1), 0 -> use pull-down resistor
                '''
                swaccess: "rw"
                hwaccess: "hro"
                resval: "0"
            },
            {
                bits: "7"
                name: ret_en
                desc: '''
                     Enable retention mode, active-high
                '''
                swaccess: "rw"
                hwaccess: "hro"
                resval: "0"
            },
            {
                bits: "8"
                name: st_en
                desc: '''
                     Schmitt-trigger enable, active high
                '''
                swaccess: "rw"
                hwaccess: "hro"
                resval: "0"
            },
            {
                bits: "9"
                name: tx_en
                desc: '''
                     TX driver enable, active low
                '''
                swaccess: "rw"
                hwaccess: "hro"
                resval: "0"
            },
          ]
      }

       {
          name: PAD_GPIO26_MUX_SEL
          desc: '''
              Pad signal port multiplex selection for pad pad_gpio26. The programmed value defines which port
              is connected to the pad.
          '''
          swaccess: "rw"
          hwaccess: "hro"
          resval: 0
          fields: [
              {
                  bits: "1:0"
                  enum: [
                      { value: "0", name: "register", desc: "Connects the Pad to the internal configuration register."}
                      { value: "1", name: "port_observables_s_cluster_rstn", desc: "Connect port s_cluster_rstn from port group observables to this pad." }
                      { value: "2", name: "port_observables_s_soc_rstn", desc: "Connect port s_soc_rstn from port group observables to this pad." }
                  ]
              }
          ]
      }

      {
          name: PAD_GPIO27_CFG
          desc: '''
            Pad signal configuration.
          '''
          swaccess: "rw"
          fields: [
            {
                bits: "0"
                name: chip2pad
                desc: '''
                     Connects to pad's TX driver
                '''
                swaccess: "rw"
                hwaccess: "hro"
                resval: "0"
            },
            {
                bits: "1"
                name: drv0
                desc: '''
                     Choose the driving strength of the pad. LSB = ~3mA
                '''
                swaccess: "rw"
                hwaccess: "hro"
                resval: "0"
            },
            {
                bits: "2"
                name: drv1
                desc: '''
                     Choose the driving strength of the pad. LSB = ~3mA
                '''
                swaccess: "rw"
                hwaccess: "hro"
                resval: "0"
            },
            {
                bits: "3"
                name: drv2
                desc: '''
                     Choose the driving strength of the pad. LSB = ~3mA
                '''
                swaccess: "rw"
                hwaccess: "hro"
                resval: "0"
            },
            {
                bits: "4"
                name: drv3
                desc: '''
                     Choose the driving strength of the pad. LSB = ~3mA
                '''
                swaccess: "rw"
                hwaccess: "hro"
                resval: "1"
            },
            {
                bits: "5"
                name: pull_en
                desc: '''
                     Enable pull up/down (depends on pull_sel) resistor, active-high
                '''
                swaccess: "rw"
                hwaccess: "hro"
                resval: "0"
            },
            {
                bits: "6"
                name: pull_sel
                desc: '''
                     1 -> use pull-up resistor (if pull_en == 1), 0 -> use pull-down resistor
                '''
                swaccess: "rw"
                hwaccess: "hro"
                resval: "0"
            },
            {
                bits: "7"
                name: ret_en
                desc: '''
                     Enable retention mode, active-high
                '''
                swaccess: "rw"
                hwaccess: "hro"
                resval: "0"
            },
            {
                bits: "8"
                name: st_en
                desc: '''
                     Schmitt-trigger enable, active high
                '''
                swaccess: "rw"
                hwaccess: "hro"
                resval: "0"
            },
            {
                bits: "9"
                name: tx_en
                desc: '''
                     TX driver enable, active low
                '''
                swaccess: "rw"
                hwaccess: "hro"
                resval: "0"
            },
          ]
      }

       {
          name: PAD_GPIO27_MUX_SEL
          desc: '''
              Pad signal port multiplex selection for pad pad_gpio27. The programmed value defines which port
              is connected to the pad.
          '''
          swaccess: "rw"
          hwaccess: "hro"
          resval: 0
          fields: [
              {
                  bits: "1:0"
                  enum: [
                      { value: "0", name: "register", desc: "Connects the Pad to the internal configuration register."}
                      { value: "1", name: "port_observables_s_cluster_rstn", desc: "Connect port s_cluster_rstn from port group observables to this pad." }
                      { value: "2", name: "port_observables_s_soc_rstn", desc: "Connect port s_soc_rstn from port group observables to this pad." }
                  ]
              }
          ]
      }

      {
          name: PAD_GPIO28_CFG
          desc: '''
            Pad signal configuration.
          '''
          swaccess: "rw"
          fields: [
            {
                bits: "0"
                name: chip2pad
                desc: '''
                     Connects to pad's TX driver
                '''
                swaccess: "rw"
                hwaccess: "hro"
                resval: "0"
            },
            {
                bits: "1"
                name: drv0
                desc: '''
                     Choose the driving strength of the pad. LSB = ~3mA
                '''
                swaccess: "rw"
                hwaccess: "hro"
                resval: "0"
            },
            {
                bits: "2"
                name: drv1
                desc: '''
                     Choose the driving strength of the pad. LSB = ~3mA
                '''
                swaccess: "rw"
                hwaccess: "hro"
                resval: "0"
            },
            {
                bits: "3"
                name: drv2
                desc: '''
                     Choose the driving strength of the pad. LSB = ~3mA
                '''
                swaccess: "rw"
                hwaccess: "hro"
                resval: "0"
            },
            {
                bits: "4"
                name: drv3
                desc: '''
                     Choose the driving strength of the pad. LSB = ~3mA
                '''
                swaccess: "rw"
                hwaccess: "hro"
                resval: "1"
            },
            {
                bits: "5"
                name: pull_en
                desc: '''
                     Enable pull up/down (depends on pull_sel) resistor, active-high
                '''
                swaccess: "rw"
                hwaccess: "hro"
                resval: "0"
            },
            {
                bits: "6"
                name: pull_sel
                desc: '''
                     1 -> use pull-up resistor (if pull_en == 1), 0 -> use pull-down resistor
                '''
                swaccess: "rw"
                hwaccess: "hro"
                resval: "0"
            },
            {
                bits: "7"
                name: ret_en
                desc: '''
                     Enable retention mode, active-high
                '''
                swaccess: "rw"
                hwaccess: "hro"
                resval: "0"
            },
            {
                bits: "8"
                name: st_en
                desc: '''
                     Schmitt-trigger enable, active high
                '''
                swaccess: "rw"
                hwaccess: "hro"
                resval: "0"
            },
            {
                bits: "9"
                name: tx_en
                desc: '''
                     TX driver enable, active low
                '''
                swaccess: "rw"
                hwaccess: "hro"
                resval: "0"
            },
          ]
      }

       {
          name: PAD_GPIO28_MUX_SEL
          desc: '''
              Pad signal port multiplex selection for pad pad_gpio28. The programmed value defines which port
              is connected to the pad.
          '''
          swaccess: "rw"
          hwaccess: "hro"
          resval: 0
          fields: [
              {
                  bits: "1:0"
                  enum: [
                      { value: "0", name: "register", desc: "Connects the Pad to the internal configuration register."}
                      { value: "1", name: "port_observables_s_cluster_rstn", desc: "Connect port s_cluster_rstn from port group observables to this pad." }
                      { value: "2", name: "port_observables_s_soc_rstn", desc: "Connect port s_soc_rstn from port group observables to this pad." }
                  ]
              }
          ]
      }

      {
          name: PAD_GPIO29_CFG
          desc: '''
            Pad signal configuration.
          '''
          swaccess: "rw"
          fields: [
            {
                bits: "0"
                name: chip2pad
                desc: '''
                     Connects to pad's TX driver
                '''
                swaccess: "rw"
                hwaccess: "hro"
                resval: "0"
            },
            {
                bits: "1"
                name: drv0
                desc: '''
                     Choose the driving strength of the pad. LSB = ~3mA
                '''
                swaccess: "rw"
                hwaccess: "hro"
                resval: "0"
            },
            {
                bits: "2"
                name: drv1
                desc: '''
                     Choose the driving strength of the pad. LSB = ~3mA
                '''
                swaccess: "rw"
                hwaccess: "hro"
                resval: "0"
            },
            {
                bits: "3"
                name: drv2
                desc: '''
                     Choose the driving strength of the pad. LSB = ~3mA
                '''
                swaccess: "rw"
                hwaccess: "hro"
                resval: "0"
            },
            {
                bits: "4"
                name: drv3
                desc: '''
                     Choose the driving strength of the pad. LSB = ~3mA
                '''
                swaccess: "rw"
                hwaccess: "hro"
                resval: "1"
            },
            {
                bits: "5"
                name: pull_en
                desc: '''
                     Enable pull up/down (depends on pull_sel) resistor, active-high
                '''
                swaccess: "rw"
                hwaccess: "hro"
                resval: "0"
            },
            {
                bits: "6"
                name: pull_sel
                desc: '''
                     1 -> use pull-up resistor (if pull_en == 1), 0 -> use pull-down resistor
                '''
                swaccess: "rw"
                hwaccess: "hro"
                resval: "0"
            },
            {
                bits: "7"
                name: ret_en
                desc: '''
                     Enable retention mode, active-high
                '''
                swaccess: "rw"
                hwaccess: "hro"
                resval: "0"
            },
            {
                bits: "8"
                name: st_en
                desc: '''
                     Schmitt-trigger enable, active high
                '''
                swaccess: "rw"
                hwaccess: "hro"
                resval: "0"
            },
            {
                bits: "9"
                name: tx_en
                desc: '''
                     TX driver enable, active low
                '''
                swaccess: "rw"
                hwaccess: "hro"
                resval: "0"
            },
          ]
      }

       {
          name: PAD_GPIO29_MUX_SEL
          desc: '''
              Pad signal port multiplex selection for pad pad_gpio29. The programmed value defines which port
              is connected to the pad.
          '''
          swaccess: "rw"
          hwaccess: "hro"
          resval: 0
          fields: [
              {
                  bits: "1:0"
                  enum: [
                      { value: "0", name: "register", desc: "Connects the Pad to the internal configuration register."}
                      { value: "1", name: "port_observables_s_cluster_rstn", desc: "Connect port s_cluster_rstn from port group observables to this pad." }
                      { value: "2", name: "port_observables_s_soc_rstn", desc: "Connect port s_soc_rstn from port group observables to this pad." }
                  ]
              }
          ]
      }

      {
          name: PAD_GPIO30_CFG
          desc: '''
            Pad signal configuration.
          '''
          swaccess: "rw"
          fields: [
            {
                bits: "0"
                name: chip2pad
                desc: '''
                     Connects to pad's TX driver
                '''
                swaccess: "rw"
                hwaccess: "hro"
                resval: "0"
            },
            {
                bits: "1"
                name: drv0
                desc: '''
                     Choose the driving strength of the pad. LSB = ~3mA
                '''
                swaccess: "rw"
                hwaccess: "hro"
                resval: "0"
            },
            {
                bits: "2"
                name: drv1
                desc: '''
                     Choose the driving strength of the pad. LSB = ~3mA
                '''
                swaccess: "rw"
                hwaccess: "hro"
                resval: "0"
            },
            {
                bits: "3"
                name: drv2
                desc: '''
                     Choose the driving strength of the pad. LSB = ~3mA
                '''
                swaccess: "rw"
                hwaccess: "hro"
                resval: "0"
            },
            {
                bits: "4"
                name: drv3
                desc: '''
                     Choose the driving strength of the pad. LSB = ~3mA
                '''
                swaccess: "rw"
                hwaccess: "hro"
                resval: "1"
            },
            {
                bits: "5"
                name: pull_en
                desc: '''
                     Enable pull up/down (depends on pull_sel) resistor, active-high
                '''
                swaccess: "rw"
                hwaccess: "hro"
                resval: "0"
            },
            {
                bits: "6"
                name: pull_sel
                desc: '''
                     1 -> use pull-up resistor (if pull_en == 1), 0 -> use pull-down resistor
                '''
                swaccess: "rw"
                hwaccess: "hro"
                resval: "0"
            },
            {
                bits: "7"
                name: ret_en
                desc: '''
                     Enable retention mode, active-high
                '''
                swaccess: "rw"
                hwaccess: "hro"
                resval: "0"
            },
            {
                bits: "8"
                name: st_en
                desc: '''
                     Schmitt-trigger enable, active high
                '''
                swaccess: "rw"
                hwaccess: "hro"
                resval: "0"
            },
            {
                bits: "9"
                name: tx_en
                desc: '''
                     TX driver enable, active low
                '''
                swaccess: "rw"
                hwaccess: "hro"
                resval: "0"
            },
          ]
      }

       {
          name: PAD_GPIO30_MUX_SEL
          desc: '''
              Pad signal port multiplex selection for pad pad_gpio30. The programmed value defines which port
              is connected to the pad.
          '''
          swaccess: "rw"
          hwaccess: "hro"
          resval: 0
          fields: [
              {
                  bits: "1:0"
                  enum: [
                      { value: "0", name: "register", desc: "Connects the Pad to the internal configuration register."}
                      { value: "1", name: "port_observables_s_cluster_rstn", desc: "Connect port s_cluster_rstn from port group observables to this pad." }
                      { value: "2", name: "port_observables_s_soc_rstn", desc: "Connect port s_soc_rstn from port group observables to this pad." }
                  ]
              }
          ]
      }

      {
          name: PAD_GPIO31_CFG
          desc: '''
            Pad signal configuration.
          '''
          swaccess: "rw"
          fields: [
            {
                bits: "0"
                name: chip2pad
                desc: '''
                     Connects to pad's TX driver
                '''
                swaccess: "rw"
                hwaccess: "hro"
                resval: "0"
            },
            {
                bits: "1"
                name: drv0
                desc: '''
                     Choose the driving strength of the pad. LSB = ~3mA
                '''
                swaccess: "rw"
                hwaccess: "hro"
                resval: "0"
            },
            {
                bits: "2"
                name: drv1
                desc: '''
                     Choose the driving strength of the pad. LSB = ~3mA
                '''
                swaccess: "rw"
                hwaccess: "hro"
                resval: "0"
            },
            {
                bits: "3"
                name: drv2
                desc: '''
                     Choose the driving strength of the pad. LSB = ~3mA
                '''
                swaccess: "rw"
                hwaccess: "hro"
                resval: "0"
            },
            {
                bits: "4"
                name: drv3
                desc: '''
                     Choose the driving strength of the pad. LSB = ~3mA
                '''
                swaccess: "rw"
                hwaccess: "hro"
                resval: "1"
            },
            {
                bits: "5"
                name: pull_en
                desc: '''
                     Enable pull up/down (depends on pull_sel) resistor, active-high
                '''
                swaccess: "rw"
                hwaccess: "hro"
                resval: "0"
            },
            {
                bits: "6"
                name: pull_sel
                desc: '''
                     1 -> use pull-up resistor (if pull_en == 1), 0 -> use pull-down resistor
                '''
                swaccess: "rw"
                hwaccess: "hro"
                resval: "0"
            },
            {
                bits: "7"
                name: ret_en
                desc: '''
                     Enable retention mode, active-high
                '''
                swaccess: "rw"
                hwaccess: "hro"
                resval: "0"
            },
            {
                bits: "8"
                name: st_en
                desc: '''
                     Schmitt-trigger enable, active high
                '''
                swaccess: "rw"
                hwaccess: "hro"
                resval: "0"
            },
            {
                bits: "9"
                name: tx_en
                desc: '''
                     TX driver enable, active low
                '''
                swaccess: "rw"
                hwaccess: "hro"
                resval: "0"
            },
          ]
      }

       {
          name: PAD_GPIO31_MUX_SEL
          desc: '''
              Pad signal port multiplex selection for pad pad_gpio31. The programmed value defines which port
              is connected to the pad.
          '''
          swaccess: "rw"
          hwaccess: "hro"
          resval: 0
          fields: [
              {
                  bits: "1:0"
                  enum: [
                      { value: "0", name: "register", desc: "Connects the Pad to the internal configuration register."}
                      { value: "1", name: "port_observables_s_cluster_rstn", desc: "Connect port s_cluster_rstn from port group observables to this pad." }
                      { value: "2", name: "port_observables_s_soc_rstn", desc: "Connect port s_soc_rstn from port group observables to this pad." }
                  ]
              }
          ]
      }

      {
          name: PAD_GPIO32_CFG
          desc: '''
            Pad signal configuration.
          '''
          swaccess: "rw"
          fields: [
            {
                bits: "0"
                name: chip2pad
                desc: '''
                     Connects to pad's TX driver
                '''
                swaccess: "rw"
                hwaccess: "hro"
                resval: "0"
            },
            {
                bits: "1"
                name: drv0
                desc: '''
                     Choose the driving strength of the pad. LSB = ~3mA
                '''
                swaccess: "rw"
                hwaccess: "hro"
                resval: "0"
            },
            {
                bits: "2"
                name: drv1
                desc: '''
                     Choose the driving strength of the pad. LSB = ~3mA
                '''
                swaccess: "rw"
                hwaccess: "hro"
                resval: "0"
            },
            {
                bits: "3"
                name: drv2
                desc: '''
                     Choose the driving strength of the pad. LSB = ~3mA
                '''
                swaccess: "rw"
                hwaccess: "hro"
                resval: "0"
            },
            {
                bits: "4"
                name: drv3
                desc: '''
                     Choose the driving strength of the pad. LSB = ~3mA
                '''
                swaccess: "rw"
                hwaccess: "hro"
                resval: "1"
            },
            {
                bits: "5"
                name: pull_en
                desc: '''
                     Enable pull up/down (depends on pull_sel) resistor, active-high
                '''
                swaccess: "rw"
                hwaccess: "hro"
                resval: "0"
            },
            {
                bits: "6"
                name: pull_sel
                desc: '''
                     1 -> use pull-up resistor (if pull_en == 1), 0 -> use pull-down resistor
                '''
                swaccess: "rw"
                hwaccess: "hro"
                resval: "0"
            },
            {
                bits: "7"
                name: ret_en
                desc: '''
                     Enable retention mode, active-high
                '''
                swaccess: "rw"
                hwaccess: "hro"
                resval: "0"
            },
            {
                bits: "8"
                name: st_en
                desc: '''
                     Schmitt-trigger enable, active high
                '''
                swaccess: "rw"
                hwaccess: "hro"
                resval: "0"
            },
            {
                bits: "9"
                name: tx_en
                desc: '''
                     TX driver enable, active low
                '''
                swaccess: "rw"
                hwaccess: "hro"
                resval: "0"
            },
          ]
      }

       {
          name: PAD_GPIO32_MUX_SEL
          desc: '''
              Pad signal port multiplex selection for pad pad_gpio32. The programmed value defines which port
              is connected to the pad.
          '''
          swaccess: "rw"
          hwaccess: "hro"
          resval: 0
          fields: [
              {
                  bits: "1:0"
                  enum: [
                      { value: "0", name: "register", desc: "Connects the Pad to the internal configuration register."}
                      { value: "1", name: "port_observables_s_cluster_rstn", desc: "Connect port s_cluster_rstn from port group observables to this pad." }
                      { value: "2", name: "port_observables_s_soc_rstn", desc: "Connect port s_soc_rstn from port group observables to this pad." }
                  ]
              }
          ]
      }

      {
          name: PAD_GPIO33_CFG
          desc: '''
            Pad signal configuration.
          '''
          swaccess: "rw"
          fields: [
            {
                bits: "0"
                name: chip2pad
                desc: '''
                     Connects to pad's TX driver
                '''
                swaccess: "rw"
                hwaccess: "hro"
                resval: "0"
            },
            {
                bits: "1"
                name: drv0
                desc: '''
                     Choose the driving strength of the pad. LSB = ~3mA
                '''
                swaccess: "rw"
                hwaccess: "hro"
                resval: "0"
            },
            {
                bits: "2"
                name: drv1
                desc: '''
                     Choose the driving strength of the pad. LSB = ~3mA
                '''
                swaccess: "rw"
                hwaccess: "hro"
                resval: "0"
            },
            {
                bits: "3"
                name: drv2
                desc: '''
                     Choose the driving strength of the pad. LSB = ~3mA
                '''
                swaccess: "rw"
                hwaccess: "hro"
                resval: "0"
            },
            {
                bits: "4"
                name: drv3
                desc: '''
                     Choose the driving strength of the pad. LSB = ~3mA
                '''
                swaccess: "rw"
                hwaccess: "hro"
                resval: "1"
            },
            {
                bits: "5"
                name: pull_en
                desc: '''
                     Enable pull up/down (depends on pull_sel) resistor, active-high
                '''
                swaccess: "rw"
                hwaccess: "hro"
                resval: "0"
            },
            {
                bits: "6"
                name: pull_sel
                desc: '''
                     1 -> use pull-up resistor (if pull_en == 1), 0 -> use pull-down resistor
                '''
                swaccess: "rw"
                hwaccess: "hro"
                resval: "0"
            },
            {
                bits: "7"
                name: ret_en
                desc: '''
                     Enable retention mode, active-high
                '''
                swaccess: "rw"
                hwaccess: "hro"
                resval: "0"
            },
            {
                bits: "8"
                name: st_en
                desc: '''
                     Schmitt-trigger enable, active high
                '''
                swaccess: "rw"
                hwaccess: "hro"
                resval: "0"
            },
            {
                bits: "9"
                name: tx_en
                desc: '''
                     TX driver enable, active low
                '''
                swaccess: "rw"
                hwaccess: "hro"
                resval: "0"
            },
          ]
      }

       {
          name: PAD_GPIO33_MUX_SEL
          desc: '''
              Pad signal port multiplex selection for pad pad_gpio33. The programmed value defines which port
              is connected to the pad.
          '''
          swaccess: "rw"
          hwaccess: "hro"
          resval: 0
          fields: [
              {
                  bits: "1:0"
                  enum: [
                      { value: "0", name: "register", desc: "Connects the Pad to the internal configuration register."}
                      { value: "1", name: "port_observables_s_cluster_rstn", desc: "Connect port s_cluster_rstn from port group observables to this pad." }
                      { value: "2", name: "port_observables_s_soc_rstn", desc: "Connect port s_soc_rstn from port group observables to this pad." }
                  ]
              }
          ]
      }

      {
          name: PAD_GPIO34_CFG
          desc: '''
            Pad signal configuration.
          '''
          swaccess: "rw"
          fields: [
            {
                bits: "0"
                name: chip2pad
                desc: '''
                     Connects to pad's TX driver
                '''
                swaccess: "rw"
                hwaccess: "hro"
                resval: "0"
            },
            {
                bits: "1"
                name: drv0
                desc: '''
                     Choose the driving strength of the pad. LSB = ~3mA
                '''
                swaccess: "rw"
                hwaccess: "hro"
                resval: "0"
            },
            {
                bits: "2"
                name: drv1
                desc: '''
                     Choose the driving strength of the pad. LSB = ~3mA
                '''
                swaccess: "rw"
                hwaccess: "hro"
                resval: "0"
            },
            {
                bits: "3"
                name: drv2
                desc: '''
                     Choose the driving strength of the pad. LSB = ~3mA
                '''
                swaccess: "rw"
                hwaccess: "hro"
                resval: "0"
            },
            {
                bits: "4"
                name: drv3
                desc: '''
                     Choose the driving strength of the pad. LSB = ~3mA
                '''
                swaccess: "rw"
                hwaccess: "hro"
                resval: "1"
            },
            {
                bits: "5"
                name: pull_en
                desc: '''
                     Enable pull up/down (depends on pull_sel) resistor, active-high
                '''
                swaccess: "rw"
                hwaccess: "hro"
                resval: "0"
            },
            {
                bits: "6"
                name: pull_sel
                desc: '''
                     1 -> use pull-up resistor (if pull_en == 1), 0 -> use pull-down resistor
                '''
                swaccess: "rw"
                hwaccess: "hro"
                resval: "0"
            },
            {
                bits: "7"
                name: ret_en
                desc: '''
                     Enable retention mode, active-high
                '''
                swaccess: "rw"
                hwaccess: "hro"
                resval: "0"
            },
            {
                bits: "8"
                name: st_en
                desc: '''
                     Schmitt-trigger enable, active high
                '''
                swaccess: "rw"
                hwaccess: "hro"
                resval: "0"
            },
            {
                bits: "9"
                name: tx_en
                desc: '''
                     TX driver enable, active low
                '''
                swaccess: "rw"
                hwaccess: "hro"
                resval: "0"
            },
          ]
      }

       {
          name: PAD_GPIO34_MUX_SEL
          desc: '''
              Pad signal port multiplex selection for pad pad_gpio34. The programmed value defines which port
              is connected to the pad.
          '''
          swaccess: "rw"
          hwaccess: "hro"
          resval: 0
          fields: [
              {
                  bits: "1:0"
                  enum: [
                      { value: "0", name: "register", desc: "Connects the Pad to the internal configuration register."}
                      { value: "1", name: "port_observables_s_cluster_rstn", desc: "Connect port s_cluster_rstn from port group observables to this pad." }
                      { value: "2", name: "port_observables_s_soc_rstn", desc: "Connect port s_soc_rstn from port group observables to this pad." }
                  ]
              }
          ]
      }

      {
          name: PAD_GPIO35_CFG
          desc: '''
            Pad signal configuration.
          '''
          swaccess: "rw"
          fields: [
            {
                bits: "0"
                name: chip2pad
                desc: '''
                     Connects to pad's TX driver
                '''
                swaccess: "rw"
                hwaccess: "hro"
                resval: "0"
            },
            {
                bits: "1"
                name: drv0
                desc: '''
                     Choose the driving strength of the pad. LSB = ~3mA
                '''
                swaccess: "rw"
                hwaccess: "hro"
                resval: "0"
            },
            {
                bits: "2"
                name: drv1
                desc: '''
                     Choose the driving strength of the pad. LSB = ~3mA
                '''
                swaccess: "rw"
                hwaccess: "hro"
                resval: "0"
            },
            {
                bits: "3"
                name: drv2
                desc: '''
                     Choose the driving strength of the pad. LSB = ~3mA
                '''
                swaccess: "rw"
                hwaccess: "hro"
                resval: "0"
            },
            {
                bits: "4"
                name: drv3
                desc: '''
                     Choose the driving strength of the pad. LSB = ~3mA
                '''
                swaccess: "rw"
                hwaccess: "hro"
                resval: "1"
            },
            {
                bits: "5"
                name: pull_en
                desc: '''
                     Enable pull up/down (depends on pull_sel) resistor, active-high
                '''
                swaccess: "rw"
                hwaccess: "hro"
                resval: "0"
            },
            {
                bits: "6"
                name: pull_sel
                desc: '''
                     1 -> use pull-up resistor (if pull_en == 1), 0 -> use pull-down resistor
                '''
                swaccess: "rw"
                hwaccess: "hro"
                resval: "0"
            },
            {
                bits: "7"
                name: ret_en
                desc: '''
                     Enable retention mode, active-high
                '''
                swaccess: "rw"
                hwaccess: "hro"
                resval: "0"
            },
            {
                bits: "8"
                name: st_en
                desc: '''
                     Schmitt-trigger enable, active high
                '''
                swaccess: "rw"
                hwaccess: "hro"
                resval: "0"
            },
            {
                bits: "9"
                name: tx_en
                desc: '''
                     TX driver enable, active low
                '''
                swaccess: "rw"
                hwaccess: "hro"
                resval: "0"
            },
          ]
      }

       {
          name: PAD_GPIO35_MUX_SEL
          desc: '''
              Pad signal port multiplex selection for pad pad_gpio35. The programmed value defines which port
              is connected to the pad.
          '''
          swaccess: "rw"
          hwaccess: "hro"
          resval: 0
          fields: [
              {
                  bits: "1:0"
                  enum: [
                      { value: "0", name: "register", desc: "Connects the Pad to the internal configuration register."}
                      { value: "1", name: "port_observables_s_cluster_rstn", desc: "Connect port s_cluster_rstn from port group observables to this pad." }
                      { value: "2", name: "port_observables_s_soc_rstn", desc: "Connect port s_soc_rstn from port group observables to this pad." }
                  ]
              }
          ]
      }

      {
          name: PAD_GPIO36_CFG
          desc: '''
            Pad signal configuration.
          '''
          swaccess: "rw"
          fields: [
            {
                bits: "0"
                name: chip2pad
                desc: '''
                     Connects to pad's TX driver
                '''
                swaccess: "rw"
                hwaccess: "hro"
                resval: "0"
            },
            {
                bits: "1"
                name: drv0
                desc: '''
                     Choose the driving strength of the pad. LSB = ~3mA
                '''
                swaccess: "rw"
                hwaccess: "hro"
                resval: "0"
            },
            {
                bits: "2"
                name: drv1
                desc: '''
                     Choose the driving strength of the pad. LSB = ~3mA
                '''
                swaccess: "rw"
                hwaccess: "hro"
                resval: "0"
            },
            {
                bits: "3"
                name: drv2
                desc: '''
                     Choose the driving strength of the pad. LSB = ~3mA
                '''
                swaccess: "rw"
                hwaccess: "hro"
                resval: "0"
            },
            {
                bits: "4"
                name: drv3
                desc: '''
                     Choose the driving strength of the pad. LSB = ~3mA
                '''
                swaccess: "rw"
                hwaccess: "hro"
                resval: "1"
            },
            {
                bits: "5"
                name: pull_en
                desc: '''
                     Enable pull up/down (depends on pull_sel) resistor, active-high
                '''
                swaccess: "rw"
                hwaccess: "hro"
                resval: "0"
            },
            {
                bits: "6"
                name: pull_sel
                desc: '''
                     1 -> use pull-up resistor (if pull_en == 1), 0 -> use pull-down resistor
                '''
                swaccess: "rw"
                hwaccess: "hro"
                resval: "0"
            },
            {
                bits: "7"
                name: ret_en
                desc: '''
                     Enable retention mode, active-high
                '''
                swaccess: "rw"
                hwaccess: "hro"
                resval: "0"
            },
            {
                bits: "8"
                name: st_en
                desc: '''
                     Schmitt-trigger enable, active high
                '''
                swaccess: "rw"
                hwaccess: "hro"
                resval: "0"
            },
            {
                bits: "9"
                name: tx_en
                desc: '''
                     TX driver enable, active low
                '''
                swaccess: "rw"
                hwaccess: "hro"
                resval: "0"
            },
          ]
      }

       {
          name: PAD_GPIO36_MUX_SEL
          desc: '''
              Pad signal port multiplex selection for pad pad_gpio36. The programmed value defines which port
              is connected to the pad.
          '''
          swaccess: "rw"
          hwaccess: "hro"
          resval: 0
          fields: [
              {
                  bits: "1:0"
                  enum: [
                      { value: "0", name: "register", desc: "Connects the Pad to the internal configuration register."}
                      { value: "1", name: "port_observables_s_cluster_rstn", desc: "Connect port s_cluster_rstn from port group observables to this pad." }
                      { value: "2", name: "port_observables_s_soc_rstn", desc: "Connect port s_soc_rstn from port group observables to this pad." }
                  ]
              }
          ]
      }

      {
          name: PAD_GPIO37_CFG
          desc: '''
            Pad signal configuration.
          '''
          swaccess: "rw"
          fields: [
            {
                bits: "0"
                name: chip2pad
                desc: '''
                     Connects to pad's TX driver
                '''
                swaccess: "rw"
                hwaccess: "hro"
                resval: "0"
            },
            {
                bits: "1"
                name: drv0
                desc: '''
                     Choose the driving strength of the pad. LSB = ~3mA
                '''
                swaccess: "rw"
                hwaccess: "hro"
                resval: "0"
            },
            {
                bits: "2"
                name: drv1
                desc: '''
                     Choose the driving strength of the pad. LSB = ~3mA
                '''
                swaccess: "rw"
                hwaccess: "hro"
                resval: "0"
            },
            {
                bits: "3"
                name: drv2
                desc: '''
                     Choose the driving strength of the pad. LSB = ~3mA
                '''
                swaccess: "rw"
                hwaccess: "hro"
                resval: "0"
            },
            {
                bits: "4"
                name: drv3
                desc: '''
                     Choose the driving strength of the pad. LSB = ~3mA
                '''
                swaccess: "rw"
                hwaccess: "hro"
                resval: "1"
            },
            {
                bits: "5"
                name: pull_en
                desc: '''
                     Enable pull up/down (depends on pull_sel) resistor, active-high
                '''
                swaccess: "rw"
                hwaccess: "hro"
                resval: "0"
            },
            {
                bits: "6"
                name: pull_sel
                desc: '''
                     1 -> use pull-up resistor (if pull_en == 1), 0 -> use pull-down resistor
                '''
                swaccess: "rw"
                hwaccess: "hro"
                resval: "0"
            },
            {
                bits: "7"
                name: ret_en
                desc: '''
                     Enable retention mode, active-high
                '''
                swaccess: "rw"
                hwaccess: "hro"
                resval: "0"
            },
            {
                bits: "8"
                name: st_en
                desc: '''
                     Schmitt-trigger enable, active high
                '''
                swaccess: "rw"
                hwaccess: "hro"
                resval: "0"
            },
            {
                bits: "9"
                name: tx_en
                desc: '''
                     TX driver enable, active low
                '''
                swaccess: "rw"
                hwaccess: "hro"
                resval: "0"
            },
          ]
      }

       {
          name: PAD_GPIO37_MUX_SEL
          desc: '''
              Pad signal port multiplex selection for pad pad_gpio37. The programmed value defines which port
              is connected to the pad.
          '''
          swaccess: "rw"
          hwaccess: "hro"
          resval: 0
          fields: [
              {
                  bits: "1:0"
                  enum: [
                      { value: "0", name: "register", desc: "Connects the Pad to the internal configuration register."}
                      { value: "1", name: "port_observables_s_cluster_rstn", desc: "Connect port s_cluster_rstn from port group observables to this pad." }
                      { value: "2", name: "port_observables_s_soc_rstn", desc: "Connect port s_soc_rstn from port group observables to this pad." }
                  ]
              }
          ]
      }

      {
          name: PAD_GPIO38_CFG
          desc: '''
            Pad signal configuration.
          '''
          swaccess: "rw"
          fields: [
            {
                bits: "0"
                name: chip2pad
                desc: '''
                     Connects to pad's TX driver
                '''
                swaccess: "rw"
                hwaccess: "hro"
                resval: "0"
            },
            {
                bits: "1"
                name: drv0
                desc: '''
                     Choose the driving strength of the pad. LSB = ~3mA
                '''
                swaccess: "rw"
                hwaccess: "hro"
                resval: "0"
            },
            {
                bits: "2"
                name: drv1
                desc: '''
                     Choose the driving strength of the pad. LSB = ~3mA
                '''
                swaccess: "rw"
                hwaccess: "hro"
                resval: "0"
            },
            {
                bits: "3"
                name: drv2
                desc: '''
                     Choose the driving strength of the pad. LSB = ~3mA
                '''
                swaccess: "rw"
                hwaccess: "hro"
                resval: "0"
            },
            {
                bits: "4"
                name: drv3
                desc: '''
                     Choose the driving strength of the pad. LSB = ~3mA
                '''
                swaccess: "rw"
                hwaccess: "hro"
                resval: "1"
            },
            {
                bits: "5"
                name: pull_en
                desc: '''
                     Enable pull up/down (depends on pull_sel) resistor, active-high
                '''
                swaccess: "rw"
                hwaccess: "hro"
                resval: "0"
            },
            {
                bits: "6"
                name: pull_sel
                desc: '''
                     1 -> use pull-up resistor (if pull_en == 1), 0 -> use pull-down resistor
                '''
                swaccess: "rw"
                hwaccess: "hro"
                resval: "0"
            },
            {
                bits: "7"
                name: ret_en
                desc: '''
                     Enable retention mode, active-high
                '''
                swaccess: "rw"
                hwaccess: "hro"
                resval: "0"
            },
            {
                bits: "8"
                name: st_en
                desc: '''
                     Schmitt-trigger enable, active high
                '''
                swaccess: "rw"
                hwaccess: "hro"
                resval: "0"
            },
            {
                bits: "9"
                name: tx_en
                desc: '''
                     TX driver enable, active low
                '''
                swaccess: "rw"
                hwaccess: "hro"
                resval: "0"
            },
          ]
      }

       {
          name: PAD_GPIO38_MUX_SEL
          desc: '''
              Pad signal port multiplex selection for pad pad_gpio38. The programmed value defines which port
              is connected to the pad.
          '''
          swaccess: "rw"
          hwaccess: "hro"
          resval: 0
          fields: [
              {
                  bits: "1:0"
                  enum: [
                      { value: "0", name: "register", desc: "Connects the Pad to the internal configuration register."}
                      { value: "1", name: "port_observables_s_cluster_rstn", desc: "Connect port s_cluster_rstn from port group observables to this pad." }
                      { value: "2", name: "port_observables_s_soc_rstn", desc: "Connect port s_soc_rstn from port group observables to this pad." }
                  ]
              }
          ]
      }

      {
          name: PAD_GPIO39_CFG
          desc: '''
            Pad signal configuration.
          '''
          swaccess: "rw"
          fields: [
            {
                bits: "0"
                name: chip2pad
                desc: '''
                     Connects to pad's TX driver
                '''
                swaccess: "rw"
                hwaccess: "hro"
                resval: "0"
            },
            {
                bits: "1"
                name: drv0
                desc: '''
                     Choose the driving strength of the pad. LSB = ~3mA
                '''
                swaccess: "rw"
                hwaccess: "hro"
                resval: "0"
            },
            {
                bits: "2"
                name: drv1
                desc: '''
                     Choose the driving strength of the pad. LSB = ~3mA
                '''
                swaccess: "rw"
                hwaccess: "hro"
                resval: "0"
            },
            {
                bits: "3"
                name: drv2
                desc: '''
                     Choose the driving strength of the pad. LSB = ~3mA
                '''
                swaccess: "rw"
                hwaccess: "hro"
                resval: "0"
            },
            {
                bits: "4"
                name: drv3
                desc: '''
                     Choose the driving strength of the pad. LSB = ~3mA
                '''
                swaccess: "rw"
                hwaccess: "hro"
                resval: "1"
            },
            {
                bits: "5"
                name: pull_en
                desc: '''
                     Enable pull up/down (depends on pull_sel) resistor, active-high
                '''
                swaccess: "rw"
                hwaccess: "hro"
                resval: "0"
            },
            {
                bits: "6"
                name: pull_sel
                desc: '''
                     1 -> use pull-up resistor (if pull_en == 1), 0 -> use pull-down resistor
                '''
                swaccess: "rw"
                hwaccess: "hro"
                resval: "0"
            },
            {
                bits: "7"
                name: ret_en
                desc: '''
                     Enable retention mode, active-high
                '''
                swaccess: "rw"
                hwaccess: "hro"
                resval: "0"
            },
            {
                bits: "8"
                name: st_en
                desc: '''
                     Schmitt-trigger enable, active high
                '''
                swaccess: "rw"
                hwaccess: "hro"
                resval: "0"
            },
            {
                bits: "9"
                name: tx_en
                desc: '''
                     TX driver enable, active low
                '''
                swaccess: "rw"
                hwaccess: "hro"
                resval: "0"
            },
          ]
      }

       {
          name: PAD_GPIO39_MUX_SEL
          desc: '''
              Pad signal port multiplex selection for pad pad_gpio39. The programmed value defines which port
              is connected to the pad.
          '''
          swaccess: "rw"
          hwaccess: "hro"
          resval: 0
          fields: [
              {
                  bits: "1:0"
                  enum: [
                      { value: "0", name: "register", desc: "Connects the Pad to the internal configuration register."}
                      { value: "1", name: "port_observables_s_cluster_rstn", desc: "Connect port s_cluster_rstn from port group observables to this pad." }
                      { value: "2", name: "port_observables_s_soc_rstn", desc: "Connect port s_soc_rstn from port group observables to this pad." }
                  ]
              }
          ]
      }

      {
          name: PAD_GPIO40_CFG
          desc: '''
            Pad signal configuration.
          '''
          swaccess: "rw"
          fields: [
            {
                bits: "0"
                name: chip2pad
                desc: '''
                     Connects to pad's TX driver
                '''
                swaccess: "rw"
                hwaccess: "hro"
                resval: "0"
            },
            {
                bits: "1"
                name: drv0
                desc: '''
                     Choose the driving strength of the pad. LSB = ~3mA
                '''
                swaccess: "rw"
                hwaccess: "hro"
                resval: "0"
            },
            {
                bits: "2"
                name: drv1
                desc: '''
                     Choose the driving strength of the pad. LSB = ~3mA
                '''
                swaccess: "rw"
                hwaccess: "hro"
                resval: "0"
            },
            {
                bits: "3"
                name: drv2
                desc: '''
                     Choose the driving strength of the pad. LSB = ~3mA
                '''
                swaccess: "rw"
                hwaccess: "hro"
                resval: "0"
            },
            {
                bits: "4"
                name: drv3
                desc: '''
                     Choose the driving strength of the pad. LSB = ~3mA
                '''
                swaccess: "rw"
                hwaccess: "hro"
                resval: "1"
            },
            {
                bits: "5"
                name: pull_en
                desc: '''
                     Enable pull up/down (depends on pull_sel) resistor, active-high
                '''
                swaccess: "rw"
                hwaccess: "hro"
                resval: "0"
            },
            {
                bits: "6"
                name: pull_sel
                desc: '''
                     1 -> use pull-up resistor (if pull_en == 1), 0 -> use pull-down resistor
                '''
                swaccess: "rw"
                hwaccess: "hro"
                resval: "0"
            },
            {
                bits: "7"
                name: ret_en
                desc: '''
                     Enable retention mode, active-high
                '''
                swaccess: "rw"
                hwaccess: "hro"
                resval: "0"
            },
            {
                bits: "8"
                name: st_en
                desc: '''
                     Schmitt-trigger enable, active high
                '''
                swaccess: "rw"
                hwaccess: "hro"
                resval: "0"
            },
            {
                bits: "9"
                name: tx_en
                desc: '''
                     TX driver enable, active low
                '''
                swaccess: "rw"
                hwaccess: "hro"
                resval: "0"
            },
          ]
      }

       {
          name: PAD_GPIO40_MUX_SEL
          desc: '''
              Pad signal port multiplex selection for pad pad_gpio40. The programmed value defines which port
              is connected to the pad.
          '''
          swaccess: "rw"
          hwaccess: "hro"
          resval: 0
          fields: [
              {
                  bits: "1:0"
                  enum: [
                      { value: "0", name: "register", desc: "Connects the Pad to the internal configuration register."}
                      { value: "1", name: "port_observables_s_cluster_rstn", desc: "Connect port s_cluster_rstn from port group observables to this pad." }
                      { value: "2", name: "port_observables_s_soc_rstn", desc: "Connect port s_soc_rstn from port group observables to this pad." }
                  ]
              }
          ]
      }

      {
          name: PAD_GPIO41_CFG
          desc: '''
            Pad signal configuration.
          '''
          swaccess: "rw"
          fields: [
            {
                bits: "0"
                name: chip2pad
                desc: '''
                     Connects to pad's TX driver
                '''
                swaccess: "rw"
                hwaccess: "hro"
                resval: "0"
            },
            {
                bits: "1"
                name: drv0
                desc: '''
                     Choose the driving strength of the pad. LSB = ~3mA
                '''
                swaccess: "rw"
                hwaccess: "hro"
                resval: "0"
            },
            {
                bits: "2"
                name: drv1
                desc: '''
                     Choose the driving strength of the pad. LSB = ~3mA
                '''
                swaccess: "rw"
                hwaccess: "hro"
                resval: "0"
            },
            {
                bits: "3"
                name: drv2
                desc: '''
                     Choose the driving strength of the pad. LSB = ~3mA
                '''
                swaccess: "rw"
                hwaccess: "hro"
                resval: "0"
            },
            {
                bits: "4"
                name: drv3
                desc: '''
                     Choose the driving strength of the pad. LSB = ~3mA
                '''
                swaccess: "rw"
                hwaccess: "hro"
                resval: "1"
            },
            {
                bits: "5"
                name: pull_en
                desc: '''
                     Enable pull up/down (depends on pull_sel) resistor, active-high
                '''
                swaccess: "rw"
                hwaccess: "hro"
                resval: "0"
            },
            {
                bits: "6"
                name: pull_sel
                desc: '''
                     1 -> use pull-up resistor (if pull_en == 1), 0 -> use pull-down resistor
                '''
                swaccess: "rw"
                hwaccess: "hro"
                resval: "0"
            },
            {
                bits: "7"
                name: ret_en
                desc: '''
                     Enable retention mode, active-high
                '''
                swaccess: "rw"
                hwaccess: "hro"
                resval: "0"
            },
            {
                bits: "8"
                name: st_en
                desc: '''
                     Schmitt-trigger enable, active high
                '''
                swaccess: "rw"
                hwaccess: "hro"
                resval: "0"
            },
            {
                bits: "9"
                name: tx_en
                desc: '''
                     TX driver enable, active low
                '''
                swaccess: "rw"
                hwaccess: "hro"
                resval: "0"
            },
          ]
      }

       {
          name: PAD_GPIO41_MUX_SEL
          desc: '''
              Pad signal port multiplex selection for pad pad_gpio41. The programmed value defines which port
              is connected to the pad.
          '''
          swaccess: "rw"
          hwaccess: "hro"
          resval: 0
          fields: [
              {
                  bits: "1:0"
                  enum: [
                      { value: "0", name: "register", desc: "Connects the Pad to the internal configuration register."}
                      { value: "1", name: "port_observables_s_cluster_rstn", desc: "Connect port s_cluster_rstn from port group observables to this pad." }
                      { value: "2", name: "port_observables_s_soc_rstn", desc: "Connect port s_soc_rstn from port group observables to this pad." }
                  ]
              }
          ]
      }

      {
          name: PAD_GPIO42_CFG
          desc: '''
            Pad signal configuration.
          '''
          swaccess: "rw"
          fields: [
            {
                bits: "0"
                name: chip2pad
                desc: '''
                     Connects to pad's TX driver
                '''
                swaccess: "rw"
                hwaccess: "hro"
                resval: "0"
            },
            {
                bits: "1"
                name: drv0
                desc: '''
                     Choose the driving strength of the pad. LSB = ~3mA
                '''
                swaccess: "rw"
                hwaccess: "hro"
                resval: "0"
            },
            {
                bits: "2"
                name: drv1
                desc: '''
                     Choose the driving strength of the pad. LSB = ~3mA
                '''
                swaccess: "rw"
                hwaccess: "hro"
                resval: "0"
            },
            {
                bits: "3"
                name: drv2
                desc: '''
                     Choose the driving strength of the pad. LSB = ~3mA
                '''
                swaccess: "rw"
                hwaccess: "hro"
                resval: "0"
            },
            {
                bits: "4"
                name: drv3
                desc: '''
                     Choose the driving strength of the pad. LSB = ~3mA
                '''
                swaccess: "rw"
                hwaccess: "hro"
                resval: "1"
            },
            {
                bits: "5"
                name: pull_en
                desc: '''
                     Enable pull up/down (depends on pull_sel) resistor, active-high
                '''
                swaccess: "rw"
                hwaccess: "hro"
                resval: "0"
            },
            {
                bits: "6"
                name: pull_sel
                desc: '''
                     1 -> use pull-up resistor (if pull_en == 1), 0 -> use pull-down resistor
                '''
                swaccess: "rw"
                hwaccess: "hro"
                resval: "0"
            },
            {
                bits: "7"
                name: ret_en
                desc: '''
                     Enable retention mode, active-high
                '''
                swaccess: "rw"
                hwaccess: "hro"
                resval: "0"
            },
            {
                bits: "8"
                name: st_en
                desc: '''
                     Schmitt-trigger enable, active high
                '''
                swaccess: "rw"
                hwaccess: "hro"
                resval: "0"
            },
            {
                bits: "9"
                name: tx_en
                desc: '''
                     TX driver enable, active low
                '''
                swaccess: "rw"
                hwaccess: "hro"
                resval: "0"
            },
          ]
      }

       {
          name: PAD_GPIO42_MUX_SEL
          desc: '''
              Pad signal port multiplex selection for pad pad_gpio42. The programmed value defines which port
              is connected to the pad.
          '''
          swaccess: "rw"
          hwaccess: "hro"
          resval: 0
          fields: [
              {
                  bits: "1:0"
                  enum: [
                      { value: "0", name: "register", desc: "Connects the Pad to the internal configuration register."}
                      { value: "1", name: "port_observables_s_cluster_rstn", desc: "Connect port s_cluster_rstn from port group observables to this pad." }
                      { value: "2", name: "port_observables_s_soc_rstn", desc: "Connect port s_soc_rstn from port group observables to this pad." }
                  ]
              }
          ]
      }

    ]
}
